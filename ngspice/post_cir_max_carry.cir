**5-bit Carry Lookahead Adder
.include TSMC_180nm.txt
.param SUPPLY=1.8
.global gnd vdd
.param LAMBDA=0.09u
.param width_N=0.9u
.param width_P=2*width_N

VDD vdd gnd 1.8

*  Va0 a0 gnd PULSE(0 1.8 0 0.1n 0.1n 50n 100n)
*  Va1 a1 gnd PULSE(0 1.8 0 0.1n 0.1n 50n 100n)
*  Va2 a2 gnd PULSE(0 1.8 0 0.1n 0.1n 50n 100n)
*  Va3 a3 gnd PULSE(0 1.8 0 0.1n 0.1n 50n 100n)
*  Va4 a4 gnd PULSE(0 1.8 0 0.1n 0.1n 50n 100n)

*  Vb0 b0 gnd PULSE(0 1.8 0 0.1n 0.1n 50n 100n)
*  Vb1 b1 gnd PULSE(0 1.8 0 0.1n 0.1n 50n 100n)
*  Vb2 b2 gnd PULSE(0 1.8 0 0.1n 0.1n 50n 100n)
*  Vb3 b3 gnd PULSE(0 1.8 0 0.1n 0.1n 50n 100n)
*  Vb4 b4 gnd PULSE(0 1.8 0 0.1n 0.1n 50n 100n)

Va0 a0 gnd 1.8
Va1 a1 gnd 1.8
Va2 a2 gnd 1.8
Va3 a3 gnd 1.8
Va4 a4 gnd 1.8

Vb0 b0 gnd PULSE(0 1.8 0 0.1n 0.1n 50n 100n)
Vb1 b1 gnd 0
Vb2 b2 gnd 0
Vb3 b3 gnd 0
Vb4 b4 gnd 0

.option scale=0.09u

M1000 m1_48_33# a0 vdd 2NAND1_0/w_n10_n2# CMOSP w=20 l=2
+  ad=120 pd=52 as=7543 ps=3440
M1001 m1_48_33# b0 2NAND1_0/a_3_n40# gnd CMOSN w=20 l=2
+  ad=100 pd=50 as=120 ps=52
M1002 2NAND1_0/a_3_n40# a0 gnd gnd CMOSN w=20 l=2
+  ad=0 pd=0 as=4616 ps=2341
M1003 vdd b0 m1_48_33# 2NAND1_0/w_n10_n2# CMOSP w=20 l=2
+  ad=0 pd=0 as=0 ps=0
M1004 a_720_432# m1_48_33# gnd gnd CMOSN w=10 l=2
+  ad=70 pd=34 as=0 ps=0
M1005 a_720_432# m1_48_33# vdd inverter1_0/w_n19_78# CMOSP w=20 l=2
+  ad=140 pd=54 as=0 ps=0
M1006 a_3421_2429# c4 gnd gnd CMOSN w=10 l=2
+  ad=70 pd=34 as=0 ps=0
M1007 a_3421_2429# c4 vdd inverter1_1/w_n19_78# CMOSP w=20 l=2
+  ad=140 pd=54 as=0 ps=0
M1008 a_3409_2500# p4 gnd gnd CMOSN w=10 l=2
+  ad=70 pd=34 as=0 ps=0
M1009 a_3409_2500# p4 vdd inverter1_2/w_n19_78# CMOSP w=20 l=2
+  ad=140 pd=54 as=0 ps=0
M1010 a_3451_1603# a_932_1072# gnd gnd CMOSN w=10 l=2
+  ad=70 pd=34 as=0 ps=0
M1011 a_3451_1603# a_932_1072# vdd inverter1_3/w_n19_78# CMOSP w=20 l=2
+  ad=140 pd=54 as=0 ps=0
M1012 a_3439_1674# p3 gnd gnd CMOSN w=10 l=2
+  ad=70 pd=34 as=0 ps=0
M1013 a_3439_1674# p3 vdd inverter1_4/w_n19_78# CMOSP w=20 l=2
+  ad=140 pd=54 as=0 ps=0
M1014 a_3420_417# a_824_400# gnd gnd CMOSN w=10 l=2
+  ad=70 pd=34 as=0 ps=0
M1015 a_3420_417# a_824_400# vdd inverter1_5/w_n19_78# CMOSP w=20 l=2
+  ad=140 pd=54 as=0 ps=0
M1016 a_3408_488# p2 gnd gnd CMOSN w=10 l=2
+  ad=70 pd=34 as=0 ps=0
M1017 a_3408_488# p2 vdd inverter1_6/w_n19_78# CMOSP w=20 l=2
+  ad=140 pd=54 as=0 ps=0
M1018 a_3416_39# a_720_432# gnd gnd CMOSN w=10 l=2
+  ad=70 pd=34 as=0 ps=0
M1019 a_3416_39# a_720_432# vdd inverter1_7/w_n19_78# CMOSP w=20 l=2
+  ad=140 pd=54 as=0 ps=0
M1020 2XOR_0/a_125_49# a0 gnd gnd CMOSN w=10 l=2
+  ad=70 pd=34 as=0 ps=0
M1021 2XOR_0/a_125_49# a0 vdd 2XOR_0/inverter1_0/w_n19_78# CMOSP w=20 l=2
+  ad=140 pd=54 as=0 ps=0
M1022 2XOR_0/a_137_n22# b0 gnd gnd CMOSN w=10 l=2
+  ad=70 pd=34 as=0 ps=0
M1023 2XOR_0/a_137_n22# b0 vdd 2XOR_0/inverter1_1/w_n19_78# CMOSP w=20 l=2
+  ad=140 pd=54 as=0 ps=0
M1024 p0 2XOR_0/a_125_49# 2XOR_0/a_79_14# 2XOR_0/w_118_6# CMOSP w=20 l=2
+  ad=120 pd=52 as=320 ps=152
M1025 2XOR_0/a_79_14# a0 vdd 2XOR_0/w_66_6# CMOSP w=20 l=2
+  ad=0 pd=0 as=0 ps=0
M1026 2XOR_0/a_79_n18# a0 gnd gnd CMOSN w=10 l=2
+  ad=60 pd=32 as=0 ps=0
M1027 2XOR_0/a_131_n18# 2XOR_0/a_125_49# p0 gnd CMOSN w=10 l=2
+  ad=60 pd=32 as=100 ps=60
M1028 2XOR_0/a_79_14# 2XOR_0/a_137_n22# p0 2XOR_0/w_118_6# CMOSP w=20 l=2
+  ad=0 pd=0 as=0 ps=0
M1029 vdd b0 2XOR_0/a_79_14# 2XOR_0/w_66_6# CMOSP w=20 l=2
+  ad=0 pd=0 as=0 ps=0
M1030 p0 b0 2XOR_0/a_79_n18# gnd CMOSN w=10 l=2
+  ad=0 pd=0 as=0 ps=0
M1031 gnd 2XOR_0/a_137_n22# 2XOR_0/a_131_n18# gnd CMOSN w=10 l=2
+  ad=0 pd=0 as=0 ps=0
M1032 a_3404_110# p1 gnd gnd CMOSN w=10 l=2
+  ad=70 pd=34 as=0 ps=0
M1033 a_3404_110# p1 vdd inverter1_8/w_n19_78# CMOSP w=20 l=2
+  ad=140 pd=54 as=0 ps=0
M1034 a_3416_n409# gnd gnd gnd CMOSN w=10 l=2
+  ad=70 pd=34 as=0 ps=0
M1035 a_3416_n409# gnd vdd inverter1_9/w_n19_78# CMOSP w=20 l=2
+  ad=140 pd=54 as=0 ps=0
M1036 a_3404_n338# p0 gnd gnd CMOSN w=10 l=2
+  ad=70 pd=34 as=0 ps=0
M1037 a_3404_n338# p0 vdd inverter1_10/w_n19_78# CMOSP w=20 l=2
+  ad=140 pd=54 as=0 ps=0
M1038 a_759_3032# a_179_1919# a_759_2988# gnd CMOSN w=20 l=2
+  ad=100 pd=50 as=120 ps=52
M1039 vdd a_64_1943# c4 w_1072_1940# CMOSP w=20 l=2
+  ad=0 pd=0 as=320 ps=152
M1040 s3 a_932_1072# a_3393_1607# gnd CMOSN w=10 l=2
+  ad=100 pd=60 as=60 ps=32
M1041 gnd a_759_3032# a_1060_2722# gnd CMOSN w=50 l=2
+  ad=0 pd=0 as=300 ps=112
M1042 a_3362_453# p2 vdd w_3349_445# CMOSP w=20 l=2
+  ad=320 pd=152 as=0 ps=0
M1043 a_131_775# a_19_810# p1 gnd CMOSN w=10 l=2
+  ad=60 pd=32 as=51 ps=31
M1044 a_777_1127# p2 a_769_1127# gnd CMOSN w=30 l=2
+  ad=180 pd=72 as=180 ps=72
M1045 c5 a_749_2650# vdd w_1023_2786# CMOSP w=20 l=2
+  ad=340 pd=154 as=0 ps=0
M1046 a_756_2650# p4 a_749_2650# gnd CMOSN w=40 l=2
+  ad=240 pd=92 as=200 ps=90
M1047 a_761_2104# p3 gnd gnd CMOSN w=20 l=2
+  ad=120 pd=52 as=0 ps=0
M1048 gnd a_3416_n409# a_3410_n405# gnd CMOSN w=10 l=2
+  ad=0 pd=0 as=60 ps=32
M1049 a_47_591# a1 gnd gnd CMOSN w=20 l=2
+  ad=120 pd=52 as=0 ps=0
M1050 a_1052_2722# a_749_2650# a_1044_2722# gnd CMOSN w=50 l=2
+  ad=300 pd=112 as=300 ps=112
M1051 a_3410_43# a_3404_110# s1 gnd CMOSN w=10 l=2
+  ad=60 pd=32 as=100 ps=60
M1052 a_776_1890# p2 a_768_1890# gnd CMOSN w=30 l=2
+  ad=180 pd=72 as=180 ps=72
M1053 s3 a_3439_1674# a_3393_1639# w_3432_1631# CMOSP w=20 l=2
+  ad=120 pd=52 as=320 ps=152
M1054 gnd a_761_2148# a_1101_1885# gnd CMOSN w=40 l=2
+  ad=0 pd=0 as=240 ps=92
M1055 a_19_810# a1 gnd gnd CMOSN w=10 l=2
+  ad=70 pd=34 as=0 ps=0
M1056 a_82_1415# a2 gnd gnd CMOSN w=10 l=2
+  ad=60 pd=32 as=0 ps=0
M1057 a_782_1645# p1 a_774_1645# gnd CMOSN w=40 l=2
+  ad=240 pd=92 as=240 ps=92
M1058 a_761_1890# p2 vdd w_755_1935# CMOSP w=20 l=2
+  ad=220 pd=102 as=0 ps=0
M1059 s1 a_720_432# a_3358_43# gnd CMOSN w=10 l=2
+  ad=0 pd=0 as=60 ps=32
M1060 a_115_2744# a_56_2664# p4 w_154_2736# CMOSP w=20 l=2
+  ad=320 pd=152 as=120 ps=52
M1061 vdd a_720_432# a_762_1127# w_756_1172# CMOSP w=20 l=2
+  ad=0 pd=0 as=220 ps=102
M1062 a_96_2115# a_37_2035# p3 w_135_2107# CMOSP w=20 l=2
+  ad=320 pd=152 as=120 ps=52
M1063 a_23_1367# b2 gnd gnd CMOSN w=10 l=2
+  ad=70 pd=34 as=0 ps=0
M1064 a_79_807# a1 vdd w_66_799# CMOSP w=20 l=2
+  ad=320 pd=152 as=0 ps=0
M1065 vdd a_932_1072# a_3393_1639# w_3380_1631# CMOSP w=20 l=2
+  ad=0 pd=0 as=0 ps=0
M1066 a_64_1899# a3 gnd gnd CMOSN w=20 l=2
+  ad=120 pd=52 as=0 ps=0
M1067 a_3358_n405# p0 gnd gnd CMOSN w=10 l=2
+  ad=60 pd=32 as=0 ps=0
M1068 p1 b1 a_79_775# gnd CMOSN w=10 l=2
+  ad=0 pd=0 as=60 ps=32
M1069 gnd a_165_1251# a_767_2825# gnd CMOSN w=30 l=2
+  ad=0 pd=0 as=180 ps=72
M1070 a_64_1943# a3 vdd w_51_1937# CMOSP w=20 l=2
+  ad=120 pd=52 as=0 ps=0
M1071 s1 a_3404_110# a_3358_75# w_3397_67# CMOSP w=20 l=2
+  ad=120 pd=52 as=320 ps=152
M1072 a_3358_n373# a_3416_n409# s0 w_3397_n381# CMOSP w=20 l=2
+  ad=320 pd=152 as=120 ps=52
M1073 vdd p4 a_752_2825# w_746_2870# CMOSP w=20 l=2
+  ad=0 pd=0 as=220 ps=102
M1074 a_3415_2433# a_3409_2500# s4 gnd CMOSN w=10 l=2
+  ad=60 pd=32 as=100 ps=60
M1075 a_759_3032# p4 vdd w_746_3026# CMOSP w=20 l=2
+  ad=120 pd=52 as=0 ps=0
M1076 p1 a_19_810# a_79_807# w_118_799# CMOSP w=20 l=2
+  ad=120 pd=52 as=0 ps=0
M1077 vdd a_162_611# a_775_1022# w_762_1016# CMOSP w=20 l=2
+  ad=0 pd=0 as=120 ps=52
M1078 gnd a_20_727# a_131_775# gnd CMOSN w=10 l=2
+  ad=0 pd=0 as=0 ps=0
M1079 a_19_810# a1 vdd w_3_836# CMOSP w=20 l=2
+  ad=140 pd=54 as=0 ps=0
M1080 a_82_1447# a2 vdd w_69_1439# CMOSP w=20 l=2
+  ad=320 pd=152 as=0 ps=0
M1081 vdd a_720_432# a_3358_75# w_3345_67# CMOSP w=20 l=2
+  ad=0 pd=0 as=0 ps=0
M1082 a_162_611# a_47_635# gnd gnd CMOSN w=10 l=2
+  ad=70 pd=34 as=0 ps=0
M1083 a_939_1072# a_50_1275# a_932_1072# gnd CMOSN w=30 l=2
+  ad=180 pd=72 as=150 ps=70
M1084 gnd p1 a_782_2471# gnd CMOSN w=50 l=2
+  ad=0 pd=0 as=300 ps=112
M1085 a_761_2148# p3 vdd w_748_2142# CMOSP w=20 l=2
+  ad=120 pd=52 as=0 ps=0
M1086 a_47_635# b1 a_47_591# gnd CMOSN w=20 l=2
+  ad=100 pd=50 as=0 ps=0
M1087 a_134_1415# a_22_1450# p2 gnd CMOSN w=10 l=2
+  ad=60 pd=32 as=51 ps=31
M1088 a_759_1645# a_720_432# vdd w_753_1700# CMOSP w=20 l=2
+  ad=320 pd=152 as=0 ps=0
M1089 a_23_1367# b2 vdd w_7_1393# CMOSP w=20 l=2
+  ad=140 pd=54 as=0 ps=0
M1090 gnd a_3451_1603# a_3445_1607# gnd CMOSN w=10 l=2
+  ad=0 pd=0 as=60 ps=32
M1091 s4 c4 a_3363_2433# gnd CMOSN w=10 l=2
+  ad=0 pd=0 as=60 ps=32
M1092 a_179_1919# a_64_1943# vdd w_163_1945# CMOSP w=20 l=2
+  ad=140 pd=54 as=0 ps=0
M1093 vdd a_50_1275# a_932_1072# w_926_1117# CMOSP w=20 l=2
+  ad=0 pd=0 as=220 ps=102
M1094 a_751_2471# p1 vdd w_745_2535# CMOSP w=20 l=2
+  ad=340 pd=154 as=0 ps=0
M1095 a_774_2471# p2 a_766_2471# gnd CMOSN w=50 l=2
+  ad=300 pd=112 as=300 ps=112
M1096 a_165_1251# a_50_1275# gnd gnd CMOSN w=10 l=2
+  ad=70 pd=34 as=0 ps=0
M1097 vdd b4 a_83_2572# w_70_2566# CMOSP w=20 l=2
+  ad=0 pd=0 as=120 ps=52
M1098 a_726_356# a_720_432# gnd gnd CMOSN w=20 l=2
+  ad=120 pd=52 as=0 ps=0
M1099 a_47_635# a1 vdd w_34_629# CMOSP w=20 l=2
+  ad=120 pd=52 as=0 ps=0
M1100 vdd p2 a_749_2650# w_743_2705# CMOSP w=20 l=2
+  ad=0 pd=0 as=320 ps=152
M1101 a_759_1645# p2 vdd w_753_1700# CMOSP w=20 l=2
+  ad=0 pd=0 as=0 ps=0
M1102 c5 a_83_2572# vdd w_1023_2786# CMOSP w=20 l=2
+  ad=0 pd=0 as=0 ps=0
M1103 a_83_2572# b4 a_83_2528# gnd CMOSN w=20 l=2
+  ad=100 pd=50 as=120 ps=52
M1104 a_3358_n373# p0 vdd w_3345_n381# CMOSP w=20 l=2
+  ad=0 pd=0 as=0 ps=0
M1105 a_751_2471# p2 vdd w_745_2535# CMOSP w=20 l=2
+  ad=0 pd=0 as=0 ps=0
M1106 a_726_400# a_720_432# vdd w_713_394# CMOSP w=20 l=2
+  ad=120 pd=52 as=0 ps=0
M1107 a_1036_2722# a_83_2572# c5 gnd CMOSN w=50 l=2
+  ad=300 pd=112 as=250 ps=110
M1108 s4 a_3409_2500# a_3363_2465# w_3402_2457# CMOSP w=20 l=2
+  ad=120 pd=52 as=320 ps=152
M1109 gnd a_162_611# a_772_2650# gnd CMOSN w=40 l=2
+  ad=0 pd=0 as=240 ps=92
M1110 vdd b1 a_79_807# w_66_799# CMOSP w=20 l=2
+  ad=0 pd=0 as=0 ps=0
M1111 c4 a_759_1645# vdd w_1072_1940# CMOSP w=20 l=2
+  ad=0 pd=0 as=0 ps=0
M1112 a_50_1231# a2 gnd gnd CMOSN w=20 l=2
+  ad=120 pd=52 as=0 ps=0
M1113 a_36_2118# a3 vdd w_20_2144# CMOSP w=20 l=2
+  ad=140 pd=54 as=0 ps=0
M1114 a_761_2148# a_165_1251# a_761_2104# gnd CMOSN w=20 l=2
+  ad=100 pd=50 as=0 ps=0
M1115 a_179_1919# a_64_1943# gnd gnd CMOSN w=10 l=2
+  ad=70 pd=34 as=0 ps=0
M1116 a_162_611# a_47_635# vdd w_146_637# CMOSP w=20 l=2
+  ad=140 pd=54 as=0 ps=0
M1117 gnd a_720_432# a_777_1127# gnd CMOSN w=30 l=2
+  ad=0 pd=0 as=0 ps=0
M1118 a_766_1645# p3 a_759_1645# gnd CMOSN w=40 l=2
+  ad=240 pd=92 as=200 ps=90
M1119 a_764_2650# p3 a_756_2650# gnd CMOSN w=40 l=2
+  ad=240 pd=92 as=0 ps=0
M1120 a_1101_1885# a_761_1890# a_1093_1885# gnd CMOSN w=40 l=2
+  ad=0 pd=0 as=240 ps=92
M1121 p2 a_22_1450# a_82_1447# w_121_1439# CMOSP w=20 l=2
+  ad=120 pd=52 as=0 ps=0
M1122 a_3393_1607# p3 gnd gnd CMOSN w=10 l=2
+  ad=0 pd=0 as=0 ps=0
M1123 gnd p3 a_776_1890# gnd CMOSN w=30 l=2
+  ad=0 pd=0 as=0 ps=0
M1124 a_20_727# b1 gnd gnd CMOSN w=10 l=2
+  ad=70 pd=34 as=0 ps=0
M1125 vdd p1 a_762_1127# w_756_1172# CMOSP w=20 l=2
+  ad=0 pd=0 as=0 ps=0
M1126 a_3393_1639# a_3451_1603# s3 w_3432_1631# CMOSP w=20 l=2
+  ad=0 pd=0 as=0 ps=0
M1127 vdd c4 a_3363_2465# w_3350_2457# CMOSP w=20 l=2
+  ad=0 pd=0 as=0 ps=0
M1128 a_96_2083# a3 gnd gnd CMOSN w=10 l=2
+  ad=60 pd=32 as=0 ps=0
M1129 a_1085_1885# a_64_1943# c4 gnd CMOSN w=40 l=2
+  ad=240 pd=92 as=200 ps=90
M1130 a_79_807# a_20_727# p1 w_118_799# CMOSP w=20 l=2
+  ad=0 pd=0 as=0 ps=0
M1131 a_165_1251# a_50_1275# vdd w_149_1277# CMOSP w=20 l=2
+  ad=140 pd=54 as=0 ps=0
M1132 a_115_2712# a4 gnd gnd CMOSN w=10 l=2
+  ad=60 pd=32 as=0 ps=0
M1133 gnd a_3416_39# a_3410_43# gnd CMOSN w=10 l=2
+  ad=0 pd=0 as=0 ps=0
M1134 a_759_2825# p4 a_752_2825# gnd CMOSN w=30 l=2
+  ad=180 pd=72 as=150 ps=70
M1135 vdd p3 a_761_1890# w_755_1935# CMOSP w=20 l=2
+  ad=0 pd=0 as=0 ps=0
M1136 a_55_2747# a4 gnd gnd CMOSN w=10 l=2
+  ad=70 pd=34 as=0 ps=0
M1137 a_36_2118# a3 gnd gnd CMOSN w=10 l=2
+  ad=70 pd=34 as=0 ps=0
M1138 a_56_2664# b4 gnd gnd CMOSN w=10 l=2
+  ad=70 pd=34 as=0 ps=0
M1139 a_64_1943# b3 a_64_1899# gnd CMOSN w=20 l=2
+  ad=100 pd=50 as=0 ps=0
M1140 s0 gnd a_3358_n405# gnd CMOSN w=10 l=2
+  ad=100 pd=60 as=0 ps=0
M1141 a_726_400# p1 a_726_356# gnd CMOSN w=20 l=2
+  ad=100 pd=50 as=0 ps=0
M1142 a_37_2035# b3 gnd gnd CMOSN w=10 l=2
+  ad=70 pd=34 as=0 ps=0
M1143 vdd b1 a_47_635# w_34_629# CMOSP w=20 l=2
+  ad=0 pd=0 as=0 ps=0
M1144 vdd b3 a_64_1943# w_51_1937# CMOSP w=20 l=2
+  ad=0 pd=0 as=0 ps=0
M1145 a_3393_1639# p3 vdd w_3380_1631# CMOSP w=20 l=2
+  ad=0 pd=0 as=0 ps=0
M1146 vdd p1 a_726_400# w_713_394# CMOSP w=20 l=2
+  ad=0 pd=0 as=0 ps=0
M1147 a_752_2825# p3 vdd w_746_2870# CMOSP w=20 l=2
+  ad=0 pd=0 as=0 ps=0
M1148 gnd a_3421_2429# a_3415_2433# gnd CMOSN w=10 l=2
+  ad=0 pd=0 as=0 ps=0
M1149 a_20_727# b1 vdd w_4_753# CMOSP w=20 l=2
+  ad=140 pd=54 as=0 ps=0
M1150 vdd a_179_1919# a_759_3032# w_746_3026# CMOSP w=20 l=2
+  ad=0 pd=0 as=0 ps=0
M1151 a_115_2744# a4 vdd w_102_2736# CMOSP w=20 l=2
+  ad=0 pd=0 as=0 ps=0
M1152 a_824_356# a_726_400# gnd gnd CMOSN w=20 l=2
+  ad=120 pd=52 as=0 ps=0
M1153 a_50_1275# a2 vdd w_37_1269# CMOSP w=20 l=2
+  ad=120 pd=52 as=0 ps=0
M1154 a_758_2471# p4 a_751_2471# gnd CMOSN w=50 l=2
+  ad=300 pd=112 as=250 ps=110
M1155 a_3358_75# a_3416_39# s1 w_3397_67# CMOSP w=20 l=2
+  ad=0 pd=0 as=0 ps=0
M1156 a_148_2083# a_36_2118# p3 gnd CMOSN w=10 l=2
+  ad=60 pd=32 as=58 ps=38
M1157 a_824_400# a_726_400# vdd w_811_394# CMOSP w=20 l=2
+  ad=120 pd=52 as=0 ps=0
M1158 a_55_2747# a4 vdd w_39_2773# CMOSP w=20 l=2
+  ad=140 pd=54 as=0 ps=0
M1159 vdd p4 a_749_2650# w_743_2705# CMOSP w=20 l=2
+  ad=0 pd=0 as=0 ps=0
M1160 vdd a_165_1251# a_761_2148# w_748_2142# CMOSP w=20 l=2
+  ad=0 pd=0 as=0 ps=0
M1161 a_947_1072# a_775_1022# a_939_1072# gnd CMOSN w=30 l=2
+  ad=180 pd=72 as=0 ps=0
M1162 gnd a_23_1367# a_134_1415# gnd CMOSN w=10 l=2
+  ad=0 pd=0 as=0 ps=0
M1163 a_167_2712# a_55_2747# p4 gnd CMOSN w=10 l=2
+  ad=60 pd=32 as=100 ps=60
M1164 a_751_2471# p4 vdd w_745_2535# CMOSP w=20 l=2
+  ad=0 pd=0 as=0 ps=0
M1165 a_96_2115# a3 vdd w_83_2107# CMOSP w=20 l=2
+  ad=0 pd=0 as=0 ps=0
M1166 a_775_978# p2 gnd gnd CMOSN w=20 l=2
+  ad=120 pd=52 as=0 ps=0
M1167 a_3414_421# a_3408_488# s2 gnd CMOSN w=10 l=2
+  ad=60 pd=32 as=100 ps=60
M1168 vdd a_752_2825# c5 w_1023_2786# CMOSP w=20 l=2
+  ad=0 pd=0 as=0 ps=0
M1169 a_56_2664# b4 vdd w_40_2690# CMOSP w=20 l=2
+  ad=140 pd=54 as=0 ps=0
M1170 a_932_1072# a_775_1022# vdd w_926_1117# CMOSP w=20 l=2
+  ad=0 pd=0 as=0 ps=0
M1171 a_759_2988# p4 gnd gnd CMOSN w=20 l=2
+  ad=0 pd=0 as=0 ps=0
M1172 a_1060_2722# a_752_2825# a_1052_2722# gnd CMOSN w=50 l=2
+  ad=0 pd=0 as=0 ps=0
M1173 a_782_2471# a_720_432# a_774_2471# gnd CMOSN w=50 l=2
+  ad=0 pd=0 as=0 ps=0
M1174 a_37_2035# b3 vdd w_21_2061# CMOSP w=20 l=2
+  ad=140 pd=54 as=0 ps=0
M1175 c4 a_761_2148# vdd w_1072_1940# CMOSP w=20 l=2
+  ad=0 pd=0 as=0 ps=0
M1176 vdd p1 a_759_1645# w_753_1700# CMOSP w=20 l=2
+  ad=0 pd=0 as=0 ps=0
M1177 vdd a_751_2471# c5 w_1023_2786# CMOSP w=20 l=2
+  ad=0 pd=0 as=0 ps=0
M1178 a_3363_2433# p4 gnd gnd CMOSN w=10 l=2
+  ad=0 pd=0 as=0 ps=0
M1179 a_3410_n405# a_3404_n338# s0 gnd CMOSN w=10 l=2
+  ad=0 pd=0 as=0 ps=0
M1180 vdd gnd a_3358_n373# w_3345_n381# CMOSP w=20 l=2
+  ad=0 pd=0 as=0 ps=0
M1181 a_769_1127# p1 a_762_1127# gnd CMOSN w=30 l=2
+  ad=0 pd=0 as=150 ps=70
M1182 vdd a_720_432# a_751_2471# w_745_2535# CMOSP w=20 l=2
+  ad=0 pd=0 as=0 ps=0
M1183 a_1044_2722# a_751_2471# a_1036_2722# gnd CMOSN w=50 l=2
+  ad=0 pd=0 as=0 ps=0
M1184 a_83_2572# a4 vdd w_70_2566# CMOSP w=20 l=2
+  ad=0 pd=0 as=0 ps=0
M1185 a_3363_2465# a_3421_2429# s4 w_3402_2457# CMOSP w=20 l=2
+  ad=0 pd=0 as=0 ps=0
M1186 a_768_1890# a_162_611# a_761_1890# gnd CMOSN w=30 l=2
+  ad=0 pd=0 as=150 ps=70
M1187 p2 b2 a_82_1415# gnd CMOSN w=10 l=2
+  ad=0 pd=0 as=0 ps=0
M1188 gnd a_720_432# a_782_1645# gnd CMOSN w=40 l=2
+  ad=0 pd=0 as=0 ps=0
M1189 a_83_2528# a4 gnd gnd CMOSN w=20 l=2
+  ad=0 pd=0 as=0 ps=0
M1190 a_3358_43# p1 gnd gnd CMOSN w=10 l=2
+  ad=0 pd=0 as=0 ps=0
M1191 a_50_1275# b2 a_50_1231# gnd CMOSN w=20 l=2
+  ad=100 pd=50 as=0 ps=0
M1192 a_772_2650# p2 a_764_2650# gnd CMOSN w=40 l=2
+  ad=0 pd=0 as=0 ps=0
M1193 vdd a_162_611# a_761_1890# w_755_1935# CMOSP w=20 l=2
+  ad=0 pd=0 as=0 ps=0
M1194 a_774_1645# p2 a_766_1645# gnd CMOSN w=40 l=2
+  ad=0 pd=0 as=0 ps=0
M1195 a_82_1447# a_23_1367# p2 w_121_1439# CMOSP w=20 l=2
+  ad=0 pd=0 as=0 ps=0
M1196 p4 a_55_2747# a_115_2744# w_154_2736# CMOSP w=20 l=2
+  ad=0 pd=0 as=0 ps=0
M1197 p3 b3 a_96_2083# gnd CMOSN w=10 l=2
+  ad=0 pd=0 as=0 ps=0
M1198 s2 a_3408_488# a_3362_453# w_3401_445# CMOSP w=20 l=2
+  ad=120 pd=52 as=0 ps=0
M1199 a_762_1127# p2 vdd w_756_1172# CMOSP w=20 l=2
+  ad=0 pd=0 as=0 ps=0
M1200 p3 a_36_2118# a_96_2115# w_135_2107# CMOSP w=20 l=2
+  ad=0 pd=0 as=0 ps=0
M1201 a_824_400# a_47_635# a_824_356# gnd CMOSN w=20 l=2
+  ad=100 pd=50 as=0 ps=0
M1202 p4 b4 a_115_2712# gnd CMOSN w=10 l=2
+  ad=0 pd=0 as=0 ps=0
M1203 a_1093_1885# a_759_1645# a_1085_1885# gnd CMOSN w=40 l=2
+  ad=0 pd=0 as=0 ps=0
M1204 a_198_2548# a_83_2572# vdd w_182_2574# CMOSP w=20 l=2
+  ad=140 pd=54 as=0 ps=0
M1205 vdd a_47_635# a_824_400# w_811_394# CMOSP w=20 l=2
+  ad=0 pd=0 as=0 ps=0
M1206 a_767_2825# p3 a_759_2825# gnd CMOSN w=30 l=2
+  ad=0 pd=0 as=0 ps=0
M1207 a_3363_2465# p4 vdd w_3350_2457# CMOSP w=20 l=2
+  ad=0 pd=0 as=0 ps=0
M1208 a_775_1022# a_162_611# a_775_978# gnd CMOSN w=20 l=2
+  ad=100 pd=50 as=0 ps=0
M1209 gnd a_3420_417# a_3414_421# gnd CMOSN w=10 l=2
+  ad=0 pd=0 as=0 ps=0
M1210 s2 a_824_400# a_3362_421# gnd CMOSN w=10 l=2
+  ad=0 pd=0 as=60 ps=32
M1211 s0 a_3404_n338# a_3358_n373# w_3397_n381# CMOSP w=20 l=2
+  ad=0 pd=0 as=0 ps=0
M1212 vdd b2 a_82_1447# w_69_1439# CMOSP w=20 l=2
+  ad=0 pd=0 as=0 ps=0
M1213 a_3358_75# p1 vdd w_3345_67# CMOSP w=20 l=2
+  ad=0 pd=0 as=0 ps=0
M1214 a_22_1450# a2 gnd gnd CMOSN w=10 l=2
+  ad=70 pd=34 as=0 ps=0
M1215 a_775_1022# p2 vdd w_762_1016# CMOSP w=20 l=2
+  ad=0 pd=0 as=0 ps=0
M1216 a_3362_421# p2 gnd gnd CMOSN w=10 l=2
+  ad=0 pd=0 as=0 ps=0
M1217 a_198_2548# a_83_2572# gnd gnd CMOSN w=10 l=2
+  ad=70 pd=34 as=0 ps=0
M1218 vdd a_165_1251# a_752_2825# w_746_2870# CMOSP w=20 l=2
+  ad=0 pd=0 as=0 ps=0
M1219 a_749_2650# a_162_611# vdd w_743_2705# CMOSP w=20 l=2
+  ad=0 pd=0 as=0 ps=0
M1220 a_3445_1607# a_3439_1674# s3 gnd CMOSN w=10 l=2
+  ad=0 pd=0 as=0 ps=0
M1221 vdd b4 a_115_2744# w_102_2736# CMOSP w=20 l=2
+  ad=0 pd=0 as=0 ps=0
M1222 vdd b2 a_50_1275# w_37_1269# CMOSP w=20 l=2
+  ad=0 pd=0 as=0 ps=0
M1223 a_766_2471# p3 a_758_2471# gnd CMOSN w=50 l=2
+  ad=0 pd=0 as=0 ps=0
M1224 vdd b3 a_96_2115# w_83_2107# CMOSP w=20 l=2
+  ad=0 pd=0 as=0 ps=0
M1225 gnd a_37_2035# a_148_2083# gnd CMOSN w=10 l=2
+  ad=0 pd=0 as=0 ps=0
M1226 a_79_775# a1 gnd gnd CMOSN w=10 l=2
+  ad=0 pd=0 as=0 ps=0
M1227 a_749_2650# p3 vdd w_743_2705# CMOSP w=20 l=2
+  ad=0 pd=0 as=0 ps=0
M1228 vdd p3 a_759_1645# w_753_1700# CMOSP w=20 l=2
+  ad=0 pd=0 as=0 ps=0
M1229 gnd a_762_1127# a_947_1072# gnd CMOSN w=30 l=2
+  ad=0 pd=0 as=0 ps=0
M1230 vdd a_761_1890# c4 w_1072_1940# CMOSP w=20 l=2
+  ad=0 pd=0 as=0 ps=0
M1231 vdd p3 a_751_2471# w_745_2535# CMOSP w=20 l=2
+  ad=0 pd=0 as=0 ps=0
M1232 gnd a_56_2664# a_167_2712# gnd CMOSN w=10 l=2
+  ad=0 pd=0 as=0 ps=0
M1233 a_3362_453# a_3420_417# s2 w_3401_445# CMOSP w=20 l=2
+  ad=0 pd=0 as=0 ps=0
M1234 vdd a_824_400# a_3362_453# w_3349_445# CMOSP w=20 l=2
+  ad=0 pd=0 as=0 ps=0
M1235 c5 a_759_3032# vdd w_1023_2786# CMOSP w=20 l=2
+  ad=0 pd=0 as=0 ps=0
M1236 vdd a_762_1127# a_932_1072# w_926_1117# CMOSP w=20 l=2
+  ad=0 pd=0 as=0 ps=0
M1237 a_22_1450# a2 vdd w_6_1476# CMOSP w=20 l=2
+  ad=140 pd=54 as=0 ps=0
C0 a_56_2664# gnd 0.18fF
C1 inverter1_7/w_n19_78# vdd 0.11fF
C2 p2 gnd 0.10fF
C3 w_3345_n381# vdd 0.12fF
C4 a_768_1890# a_776_1890# 0.31fF
C5 p3 vdd 1.24fF
C6 a_720_432# gnd 0.53fF
C7 a_83_2572# a_83_2528# 0.21fF
C8 w_746_2870# vdd 0.12fF
C9 a_19_810# a_20_727# 0.17fF
C10 a3 gnd 0.22fF
C11 a_3421_2429# s4 0.13fF
C12 p3 a_165_1251# 0.68fF
C13 p1 w_745_2535# 0.12fF
C14 a_3439_1674# s3 0.08fF
C15 a_22_1450# gnd 0.37fF
C16 a_96_2083# gnd 0.10fF
C17 w_146_637# a_162_611# 0.05fF
C18 a_3408_488# w_3349_445# 0.07fF
C19 a_824_400# a_47_635# 0.08fF
C20 a_50_1231# gnd 0.21fF
C21 a_720_432# w_713_394# 0.09fF
C22 w_743_2705# vdd 0.12fF
C23 w_746_2870# a_165_1251# 0.12fF
C24 a_776_1890# gnd 0.31fF
C25 p3 a_162_611# 0.11fF
C26 a_3420_417# a_3362_453# 0.12fF
C27 a_3451_1603# a_3439_1674# 0.17fF
C28 a_720_432# a_3416_39# 0.04fF
C29 a_775_978# gnd 0.21fF
C30 a_3362_453# s2 0.72fF
C31 w_1023_2786# a_751_2471# 0.12fF
C32 s3 vdd 0.09fF
C33 w_37_1269# a2 0.09fF
C34 a_751_2471# vdd 1.39fF
C35 a_131_775# gnd 0.10fF
C36 w_37_1269# a_50_1275# 0.02fF
C37 a_115_2744# vdd 0.49fF
C38 a_3420_417# gnd 0.18fF
C39 a_3451_1603# vdd 0.21fF
C40 s2 gnd 0.05fF
C41 w_762_1016# a_775_1022# 0.02fF
C42 p3 a_37_2035# 0.13fF
C43 c4 a_761_2148# 0.15fF
C44 a_759_3032# a_752_2825# 1.85fF
C45 s1 a_3410_43# 0.14fF
C46 w_102_2736# b4 0.10fF
C47 w_3_836# a1 0.07fF
C48 p3 a_759_1645# 0.15fF
C49 c4 a_761_1890# 0.15fF
C50 a_759_2825# a_767_2825# 0.31fF
C51 w_743_2705# a_162_611# 0.14fF
C52 p2 w_745_2535# 0.12fF
C53 a_36_2118# vdd 0.21fF
C54 a_720_432# w_745_2535# 0.12fF
C55 w_163_1945# vdd 0.13fF
C56 b2 vdd 0.46fF
C57 a_55_2747# a_56_2664# 0.17fF
C58 p1 a_20_727# 0.13fF
C59 a_751_2471# a_162_611# 0.05fF
C60 inverter1_3/w_n19_78# a_932_1072# 0.06fF
C61 a_762_1127# vdd 0.93fF
C62 c4 p4 0.29fF
C63 c5 a_1036_2722# 0.57fF
C64 a1 vdd 0.75fF
C65 p4 w_746_3026# 0.09fF
C66 b0 gnd 0.22fF
C67 a_3439_1674# w_3432_1631# 0.10fF
C68 a_47_635# vdd 0.72fF
C69 a_726_400# vdd 0.73fF
C70 a_3404_n338# gnd 0.37fF
C71 2XOR_0/a_79_n18# gnd 0.10fF
C72 a_3358_75# vdd 0.49fF
C73 p2 a_82_1415# 0.10fF
C74 p2 a_761_1890# 0.15fF
C75 a_932_1072# a_939_1072# 0.36fF
C76 a_3409_2500# w_3350_2457# 0.07fF
C77 2XOR_0/inverter1_1/w_n19_78# b0 0.06fF
C78 m1_48_33# 2NAND1_0/a_3_n40# 0.21fF
C79 w_83_2107# a_36_2118# 0.07fF
C80 a_36_2118# a_37_2035# 0.17fF
C81 p4 p2 0.12fF
C82 a_162_611# a_47_635# 0.11fF
C83 p4 a_56_2664# 0.13fF
C84 b3 a_64_1943# 0.08fF
C85 w_149_1277# vdd 0.13fF
C86 c4 a_3421_2429# 0.04fF
C87 2XOR_0/a_137_n22# 2XOR_0/a_79_14# 0.12fF
C88 a_3404_n338# s0 0.08fF
C89 b2 a_82_1447# 0.08fF
C90 w_4_753# vdd 0.11fF
C91 p3 w_746_2870# 0.12fF
C92 a_1044_2722# a_1052_2722# 0.52fF
C93 a_3404_110# vdd 0.21fF
C94 2XOR_0/a_125_49# gnd 0.37fF
C95 c5 gnd 0.15fF
C96 a_761_1890# a_776_1890# 0.05fF
C97 w_3345_67# vdd 0.12fF
C98 2XOR_0/a_131_n18# p0 0.14fF
C99 inverter1_1/w_n19_78# vdd 0.11fF
C100 a_762_1127# a_769_1127# 0.36fF
C101 a_3416_n409# w_3397_n381# 0.10fF
C102 a_3415_2433# gnd 0.10fF
C103 a_3416_n409# vdd 0.21fF
C104 a_167_2712# gnd 0.10fF
C105 a_749_2650# a_772_2650# 0.05fF
C106 a_3421_2429# a_3363_2465# 0.12fF
C107 w_149_1277# a_165_1251# 0.05fF
C108 a_3439_1674# a_3393_1639# 0.51fF
C109 a_939_1072# a_947_1072# 0.31fF
C110 a_751_2471# a_782_2471# 0.05fF
C111 a1 b1 0.56fF
C112 p3 w_743_2705# 0.14fF
C113 p2 w_762_1016# 0.09fF
C114 a_1085_1885# a_1093_1885# 0.41fF
C115 a_3393_1639# vdd 0.49fF
C116 b1 a_47_635# 0.08fF
C117 p2 w_3349_445# 0.10fF
C118 p3 a_751_2471# 0.15fF
C119 a_134_1415# gnd 0.10fF
C120 a_64_1899# gnd 0.21fF
C121 inverter1_5/w_n19_78# a_3420_417# 0.05fF
C122 a_179_1919# vdd 0.46fF
C123 a_932_1072# a_3439_1674# 0.00fF
C124 a_824_400# a_3362_453# 0.08fF
C125 a_3363_2465# s4 0.72fF
C126 a_3421_2429# w_3402_2457# 0.10fF
C127 w_69_1439# a_22_1450# 0.07fF
C128 b4 vdd 0.46fF
C129 inverter1_6/w_n19_78# vdd 0.12fF
C130 a_824_400# gnd 0.09fF
C131 a_759_1645# a_774_1645# 0.05fF
C132 a_932_1072# vdd 0.94fF
C133 w_926_1117# a_762_1127# 0.12fF
C134 p3 a_36_2118# 0.08fF
C135 a_1060_2722# gnd 0.52fF
C136 a_824_356# gnd 0.21fF
C137 w_70_2566# a_83_2572# 0.02fF
C138 w_102_2736# a_55_2747# 0.07fF
C139 p3 a_148_2083# 0.14fF
C140 c4 a_64_1943# 0.15fF
C141 a_752_2825# a_759_2825# 0.36fF
C142 w_4_753# b1 0.06fF
C143 w_118_799# a_20_727# 0.10fF
C144 w_66_799# a_79_807# 0.05fF
C145 a_1101_1885# gnd 0.41fF
C146 m1_48_33# inverter1_0/w_n19_78# 0.06fF
C147 a_752_2825# c5 0.15fF
C148 w_3402_2457# s4 0.03fF
C149 a2 vdd 0.75fF
C150 w_146_637# a_47_635# 0.06fF
C151 w_21_2061# vdd 0.11fF
C152 a_3451_1603# s3 0.13fF
C153 p2 a_749_2650# 0.15fF
C154 a4 b4 0.56fF
C155 p1 a_19_810# 0.08fF
C156 w_3401_445# a_3362_453# 0.14fF
C157 a_3439_1674# w_3380_1631# 0.07fF
C158 a_50_1275# vdd 0.70fF
C159 p2 a_3408_488# 0.07fF
C160 a_932_1072# a_162_611# 0.05fF
C161 w_3397_67# s1 0.03fF
C162 w_3380_1631# vdd 0.12fF
C163 a_3439_1674# gnd 0.37fF
C164 a_3409_2500# vdd 0.21fF
C165 a_3362_453# vdd 0.49fF
C166 a_165_1251# a_50_1275# 0.05fF
C167 p0 gnd 0.49fF
C168 p2 a_23_1367# 0.13fF
C169 p2 w_755_1935# 0.12fF
C170 p2 a_64_1943# 0.07fF
C171 gnd vdd 1.31fF
C172 p4 w_3350_2457# 0.10fF
C173 a_3404_n338# a_3358_n373# 0.51fF
C174 p1 w_756_1172# 0.12fF
C175 w_20_2144# a3 0.07fF
C176 a3 b3 0.56fF
C177 b0 2XOR_0/w_66_6# 0.10fF
C178 a_720_432# inverter1_0/w_n19_78# 0.05fF
C179 w_748_2142# a_761_2148# 0.02fF
C180 w_51_1937# b3 0.09fF
C181 w_21_2061# a_37_2035# 0.05fF
C182 p4 c5 0.10fF
C183 w_135_2107# a_96_2115# 0.14fF
C184 w_7_1393# vdd 0.11fF
C185 b0 2XOR_0/a_79_14# 0.08fF
C186 w_3432_1631# s3 0.03fF
C187 a_3363_2433# gnd 0.10fF
C188 a_22_1450# a_23_1367# 0.17fF
C189 c4 p1 0.09fF
C190 a_3420_417# a_3408_488# 0.17fF
C191 a_3408_488# s2 0.08fF
C192 p4 a_167_2712# 0.14fF
C193 a_165_1251# gnd 0.17fF
C194 w_51_1937# a_64_1943# 0.02fF
C195 w_66_799# vdd 0.12fF
C196 2XOR_0/inverter1_1/w_n19_78# vdd 0.11fF
C197 a0 gnd 0.22fF
C198 a4 gnd 0.22fF
C199 w_3397_n381# s0 0.03fF
C200 w_713_394# vdd 0.15fF
C201 inverter1_10/w_n19_78# a_3404_n338# 0.05fF
C202 a_3451_1603# w_3432_1631# 0.10fF
C203 inverter1_9/w_n19_78# vdd 0.11fF
C204 a_749_2650# a_756_2650# 0.47fF
C205 c4 a_3363_2465# 0.08fF
C206 a_3416_39# vdd 0.21fF
C207 a_162_611# gnd 0.52fF
C208 a_775_1022# a_775_978# 0.21fF
C209 inverter1_8/w_n19_78# vdd 0.12fF
C210 a_751_2471# a_766_2471# 0.05fF
C211 p3 a_179_1919# 0.05fF
C212 p2 w_756_1172# 0.12fF
C213 a_932_1072# w_926_1117# 0.12fF
C214 a_20_727# a_79_807# 0.12fF
C215 a_720_432# w_756_1172# 0.12fF
C216 a_37_2035# gnd 0.18fF
C217 2XOR_0/a_125_49# 2XOR_0/w_66_6# 0.07fF
C218 w_746_3026# a_759_3032# 0.02fF
C219 a_759_1645# gnd 0.32fF
C220 a_720_432# m1_48_33# 0.04fF
C221 p1 a_83_2572# 0.10fF
C222 inverter1_5/w_n19_78# a_824_400# 0.06fF
C223 a_932_1072# p3 0.28fF
C224 inverter1_2/w_n19_78# a_3409_2500# 0.05fF
C225 a_720_432# c4 0.09fF
C226 a_47_635# a_726_400# 0.17fF
C227 w_745_2535# vdd 0.16fF
C228 2XOR_0/a_125_49# 2XOR_0/a_79_14# 0.51fF
C229 p2 p1 1.25fF
C230 w_1023_2786# a_752_2825# 0.12fF
C231 w_6_1476# a2 0.07fF
C232 a_720_432# p1 1.35fF
C233 a_752_2825# vdd 0.84fF
C234 s2 a_3362_421# 0.10fF
C235 b1 gnd 0.22fF
C236 a_3393_1639# s3 0.72fF
C237 a_55_2747# vdd 0.21fF
C238 w_926_1117# a_50_1275# 0.12fF
C239 a_3414_421# gnd 0.10fF
C240 w_3402_2457# a_3363_2465# 0.14fF
C241 a_3451_1603# a_3393_1639# 0.12fF
C242 a_165_1251# a_752_2825# 0.08fF
C243 a_3358_43# gnd 0.10fF
C244 w_40_2690# a_56_2664# 0.05fF
C245 w_154_2736# a_115_2744# 0.14fF
C246 w_118_799# a_19_810# 0.10fF
C247 w_66_799# b1 0.10fF
C248 s4 a_3415_2433# 0.14fF
C249 2XOR_0/inverter1_0/w_n19_78# 2XOR_0/a_125_49# 0.05fF
C250 a_761_2148# vdd 0.47fF
C251 a_198_2548# gnd 0.07fF
C252 p2 a_83_2572# 0.05fF
C253 a_749_2650# c5 0.15fF
C254 a4 a_55_2747# 0.12fF
C255 a_824_400# w_3349_445# 0.10fF
C256 a_720_432# a_83_2572# 0.10fF
C257 p3 w_3380_1631# 0.10fF
C258 a_761_1890# vdd 0.87fF
C259 a_782_2471# gnd 0.52fF
C260 b4 a_115_2744# 0.08fF
C261 p1 a_131_775# 0.14fF
C262 a_720_432# p2 1.18fF
C263 a_932_1072# a_3451_1603# 0.04fF
C264 a_3404_110# a_3358_75# 0.51fF
C265 a_20_727# vdd 0.21fF
C266 w_3345_67# a_3358_75# 0.05fF
C267 w_163_1945# a_179_1919# 0.05fF
C268 a_165_1251# a_761_2148# 0.08fF
C269 inverter1_5/w_n19_78# vdd 0.11fF
C270 p3 gnd 0.19fF
C271 w_3345_n381# gnd 0.10fF
C272 p4 vdd 1.23fF
C273 p2 a_22_1450# 0.08fF
C274 a_162_611# a_761_2148# 0.05fF
C275 a_1036_2722# a_1044_2722# 0.52fF
C276 gnd a_3410_n405# 0.10fF
C277 a_932_1072# a_762_1127# 0.08fF
C278 a_162_611# a_761_1890# 0.27fF
C279 w_3432_1631# a_3393_1639# 0.14fF
C280 b0 m1_48_33# 0.08fF
C281 p4 a_165_1251# 0.02fF
C282 b0 2XOR_0/a_137_n22# 0.04fF
C283 a_3404_110# w_3345_67# 0.07fF
C284 p1 w_118_799# 0.03fF
C285 vdd a_3358_n373# 0.49fF
C286 w_135_2107# a_37_2035# 0.10fF
C287 w_51_1937# a3 0.09fF
C288 w_3397_n381# a_3358_n373# 0.14fF
C289 w_69_1439# vdd 0.12fF
C290 b3 a_96_2115# 0.08fF
C291 inverter1_7/w_n19_78# a_3416_39# 0.05fF
C292 a_824_400# a_3408_488# 0.00fF
C293 a2 b2 0.56fF
C294 w_1072_1940# a_761_2148# 0.14fF
C295 a_759_2988# gnd 0.21fF
C296 w_762_1016# vdd 0.14fF
C297 s3 gnd 0.05fF
C298 2XOR_0/w_118_6# 2XOR_0/a_79_14# 0.14fF
C299 b2 a_50_1275# 0.08fF
C300 s0 a_3410_n405# 0.14fF
C301 w_1072_1940# a_761_1890# 0.14fF
C302 a_751_2471# gnd 0.35fF
C303 a_759_1645# a_761_1890# 1.41fF
C304 w_3349_445# vdd 0.12fF
C305 a_64_1943# a_64_1899# 0.21fF
C306 inverter1_10/w_n19_78# p0 0.07fF
C307 2XOR_0/a_79_14# p0 0.72fF
C308 a_50_1275# a_762_1127# 0.10fF
C309 2XOR_0/w_66_6# vdd 0.12fF
C310 a_3451_1603# gnd 0.18fF
C311 a_3421_2429# vdd 0.21fF
C312 a_769_1127# a_777_1127# 0.31fF
C313 inverter1_10/w_n19_78# vdd 0.12fF
C314 2XOR_0/a_79_14# vdd 0.49fF
C315 w_39_2773# vdd 0.12fF
C316 p3 w_745_2535# 0.12fF
C317 b1 a_20_727# 0.04fF
C318 a_19_810# a_79_807# 0.51fF
C319 c4 w_3350_2457# 0.10fF
C320 a_36_2118# gnd 0.37fF
C321 p3 a_752_2825# 0.15fF
C322 w_762_1016# a_162_611# 0.09fF
C323 b2 gnd 0.22fF
C324 a0 2XOR_0/w_66_6# 0.10fF
C325 2XOR_0/a_125_49# 2XOR_0/a_137_n22# 0.17fF
C326 a_148_2083# gnd 0.10fF
C327 a_3408_488# w_3401_445# 0.10fF
C328 inverter1_2/w_n19_78# p4 0.07fF
C329 a_762_1127# gnd 0.05fF
C330 w_70_2566# vdd 0.22fF
C331 w_746_2870# a_752_2825# 0.12fF
C332 s4 vdd 0.09fF
C333 a_3420_417# s2 0.13fF
C334 w_3350_2457# a_3363_2465# 0.05fF
C335 a1 gnd 0.22fF
C336 w_39_2773# a4 0.07fF
C337 w_1023_2786# a_749_2650# 0.12fF
C338 w_69_1439# a_82_1447# 0.05fF
C339 w_121_1439# a_23_1367# 0.10fF
C340 w_7_1393# b2 0.06fF
C341 2XOR_0/inverter1_0/w_n19_78# vdd 0.12fF
C342 a_749_2650# vdd 1.12fF
C343 a_47_635# gnd 0.09fF
C344 w_149_1277# a_50_1275# 0.06fF
C345 a_3408_488# vdd 0.21fF
C346 a_726_400# gnd 0.03fF
C347 p3 w_135_2107# 0.03fF
C348 s4 a_3363_2433# 0.10fF
C349 a_932_1072# a_3393_1639# 0.08fF
C350 w_70_2566# a4 0.09fF
C351 w_745_2535# a_751_2471# 0.18fF
C352 w_66_799# a1 0.10fF
C353 p3 a_761_1890# 0.08fF
C354 w_3_836# a_19_810# 0.05fF
C355 a_759_3032# c5 0.15fF
C356 w_20_2144# vdd 0.12fF
C357 b3 vdd 0.46fF
C358 2XOR_0/inverter1_0/w_n19_78# a0 0.07fF
C359 a_83_2572# c5 0.15fF
C360 a_23_1367# vdd 0.21fF
C361 w_755_1935# vdd 0.11fF
C362 a_64_1943# vdd 0.85fF
C363 a_55_2747# a_115_2744# 0.51fF
C364 a_749_2650# a_162_611# 0.21fF
C365 s3 a_3445_1607# 0.14fF
C366 p1 a_79_807# 0.72fF
C367 p1 w_753_1700# 0.14fF
C368 p4 p3 1.20fF
C369 a_775_1022# vdd 0.67fF
C370 w_713_394# a_726_400# 0.02fF
C371 a_824_400# p1 0.01fF
C372 a_19_810# vdd 0.21fF
C373 vdd inverter1_0/w_n19_78# 0.13fF
C374 p4 w_746_2870# 0.12fF
C375 a_3404_110# gnd 0.37fF
C376 gnd a_3358_n405# 0.10fF
C377 a_3416_39# a_3358_75# 0.12fF
C378 c4 a_1101_1885# 0.05fF
C379 a_165_1251# a_64_1943# 0.05fF
C380 a_3416_n409# gnd 0.22fF
C381 w_3380_1631# a_3393_1639# 0.05fF
C382 2XOR_0/a_131_n18# gnd 0.10fF
C383 s1 vdd 0.09fF
C384 w_3345_n381# a_3358_n373# 0.05fF
C385 p2 a_134_1415# 0.14fF
C386 w_755_1935# a_162_611# 0.12fF
C387 a_932_1072# a_50_1275# 0.15fF
C388 a_162_611# a_64_1943# 0.07fF
C389 p4 w_743_2705# 0.14fF
C390 2NAND1_0/w_n10_n2# m1_48_33# 0.02fF
C391 a_932_1072# a_947_1072# 0.05fF
C392 a_162_611# a_775_1022# 0.17fF
C393 s0 a_3358_n405# 0.10fF
C394 p4 a_751_2471# 0.15fF
C395 w_135_2107# a_36_2118# 0.10fF
C396 w_83_2107# b3 0.10fF
C397 p2 w_753_1700# 0.14fF
C398 b3 a_37_2035# 0.04fF
C399 a_932_1072# w_3380_1631# 0.10fF
C400 2XOR_0/a_137_n22# 2XOR_0/w_118_6# 0.10fF
C401 a_720_432# w_753_1700# 0.14fF
C402 a_3416_39# a_3404_110# 0.17fF
C403 a_3416_n409# s0 0.13fF
C404 a_824_400# p2 0.28fF
C405 p4 a_115_2744# 0.72fF
C406 inverter1_4/w_n19_78# a_3439_1674# 0.05fF
C407 a_720_432# a_824_400# 0.10fF
C408 a_179_1919# gnd 0.07fF
C409 w_756_1172# vdd 0.12fF
C410 2XOR_0/a_137_n22# p0 0.13fF
C411 inverter1_9/w_n19_78# a_3416_n409# 0.05fF
C412 a_3404_110# inverter1_8/w_n19_78# 0.05fF
C413 a_23_1367# a_82_1447# 0.12fF
C414 w_1072_1940# a_64_1943# 0.14fF
C415 a_767_2825# gnd 0.31fF
C416 w_34_629# vdd 0.22fF
C417 a_64_1943# a_759_1645# 0.46fF
C418 vdd m1_48_33# 0.60fF
C419 2XOR_0/a_137_n22# vdd 0.21fF
C420 b4 gnd 0.22fF
C421 inverter1_4/w_n19_78# vdd 0.12fF
C422 a_932_1072# gnd 0.11fF
C423 c4 vdd 1.17fF
C424 a_762_1127# a_777_1127# 0.05fF
C425 p1 vdd 1.34fF
C426 w_746_3026# vdd 0.15fF
C427 p2 w_121_1439# 0.03fF
C428 a_19_810# b1 0.00fF
C429 a_3363_2465# vdd 0.49fF
C430 c4 a_165_1251# 0.06fF
C431 a2 gnd 0.22fF
C432 2XOR_0/a_125_49# b0 0.00fF
C433 a_761_2104# gnd 0.21fF
C434 p1 a_165_1251# 0.16fF
C435 p3 a_749_2650# 0.15fF
C436 a_50_1275# gnd 0.09fF
C437 w_40_2690# vdd 0.11fF
C438 w_1023_2786# a_759_3032# 0.12fF
C439 a_824_400# a_3420_417# 0.04fF
C440 a_759_3032# vdd 0.48fF
C441 a_947_1072# gnd 0.31fF
C442 w_1023_2786# a_83_2572# 0.12fF
C443 p1 a_162_611# 0.27fF
C444 a_720_432# p0 0.32fF
C445 w_69_1439# b2 0.10fF
C446 w_121_1439# a_22_1450# 0.10fF
C447 a_83_2572# vdd 0.70fF
C448 a_79_775# gnd 0.10fF
C449 a_726_400# a_726_356# 0.21fF
C450 p2 vdd 1.49fF
C451 a_56_2664# vdd 0.21fF
C452 a_759_1645# a_782_1645# 0.05fF
C453 a_3409_2500# gnd 0.37fF
C454 a_720_432# vdd 0.91fF
C455 w_926_1117# a_775_1022# 0.12fF
C456 s1 a_3358_43# 0.10fF
C457 p3 w_755_1935# 0.12fF
C458 c4 w_1072_1940# 0.21fF
C459 w_182_2574# a_83_2572# 0.06fF
C460 w_154_2736# a_55_2747# 0.10fF
C461 w_743_2705# a_749_2650# 0.21fF
C462 p3 a_64_1943# 0.09fF
C463 c4 a_759_1645# 0.15fF
C464 s3 a_3393_1607# 0.10fF
C465 a_165_1251# a_83_2572# 0.01fF
C466 a_752_2825# a_767_2825# 0.05fF
C467 p1 a_759_1645# 0.25fF
C468 w_4_753# a_20_727# 0.05fF
C469 w_118_799# a_79_807# 0.14fF
C470 w_34_629# b1 0.09fF
C471 a3 vdd 0.75fF
C472 p2 a_165_1251# 0.21fF
C473 a_751_2471# a_749_2650# 1.25fF
C474 a_720_432# a_165_1251# 0.07fF
C475 w_51_1937# vdd 0.22fF
C476 a_22_1450# vdd 0.21fF
C477 a_83_2528# gnd 0.21fF
C478 a_83_2572# a_162_611# 0.05fF
C479 a_55_2747# b4 0.00fF
C480 a_824_400# w_811_394# 0.02fF
C481 a_3420_417# w_3401_445# 0.10fF
C482 w_3401_445# s2 0.03fF
C483 c4 a_1093_1885# 0.05fF
C484 p2 a_162_611# 1.00fF
C485 a_720_432# a_162_611# 0.25fF
C486 gnd s0 0.05fF
C487 a_774_2471# a_782_2471# 0.52fF
C488 inverter1_9/w_n19_78# gnd 0.06fF
C489 a_3416_39# gnd 0.18fF
C490 a_3420_417# vdd 0.21fF
C491 s2 vdd 0.09fF
C492 p2 a_82_1447# 0.72fF
C493 p2 a_759_1645# 0.15fF
C494 p4 w_154_2736# 0.03fF
C495 a_720_432# a_759_1645# 0.25fF
C496 a_3416_n409# a_3358_n373# 0.12fF
C497 p4 a_179_1919# 0.32fF
C498 b0 2NAND1_0/w_n10_n2# 0.09fF
C499 w_83_2107# a3 0.10fF
C500 w_20_2144# a_36_2118# 0.05fF
C501 a_36_2118# b3 0.00fF
C502 inverter1_4/w_n19_78# p3 0.07fF
C503 a_761_2148# a_761_2104# 0.21fF
C504 w_37_1269# vdd 0.22fF
C505 c4 p3 0.01fF
C506 inverter1_1/w_n19_78# a_3421_2429# 0.05fF
C507 p3 p1 0.19fF
C508 c5 a_1060_2722# 0.05fF
C509 b2 a_23_1367# 0.04fF
C510 a_22_1450# a_82_1447# 0.51fF
C511 w_163_1945# a_64_1943# 0.06fF
C512 a_752_2825# gnd 0.35fF
C513 b0 vdd 0.46fF
C514 a_55_2747# gnd 0.37fF
C515 a_761_1890# a_768_1890# 0.36fF
C516 w_811_394# vdd 0.14fF
C517 p0 a_3404_n338# 0.09fF
C518 2XOR_0/a_79_n18# p0 0.10fF
C519 a_762_1127# a_775_1022# 0.29fF
C520 a_749_2650# a_764_2650# 0.05fF
C521 a_83_2572# a_198_2548# 0.04fF
C522 a_115_2712# gnd 0.10fF
C523 a_3445_1607# gnd 0.10fF
C524 a_3404_n338# vdd 0.21fF
C525 a_3404_n338# w_3397_n381# 0.10fF
C526 a_751_2471# a_774_2471# 0.05fF
C527 a1 a_19_810# 0.12fF
C528 a_761_2148# gnd 0.12fF
C529 a0 b0 0.56fF
C530 p3 a_83_2572# 0.10fF
C531 a_82_1415# gnd 0.10fF
C532 a_47_635# a_47_591# 0.21fF
C533 w_102_2736# vdd 0.12fF
C534 2XOR_0/a_125_49# 2XOR_0/w_118_6# 0.10fF
C535 a_761_1890# gnd 0.23fF
C536 p1 a_751_2471# 0.25fF
C537 p3 p2 2.17fF
C538 a_720_432# inverter1_7/w_n19_78# 0.06fF
C539 a_720_432# p3 0.10fF
C540 p4 a_3409_2500# 0.12fF
C541 a_777_1127# gnd 0.31fF
C542 w_3350_2457# vdd 0.12fF
C543 2XOR_0/a_125_49# p0 0.08fF
C544 w_69_1439# a2 0.10fF
C545 w_6_1476# a_22_1450# 0.05fF
C546 a_824_400# a_824_356# 0.21fF
C547 s2 a_3414_421# 0.14fF
C548 a_20_727# gnd 0.18fF
C549 w_1023_2786# c5 0.18fF
C550 2XOR_0/a_125_49# vdd 0.21fF
C551 c5 vdd 1.24fF
C552 a_759_1645# a_766_1645# 0.47fF
C553 inverter1_3/w_n19_78# vdd 0.11fF
C554 p4 gnd 0.16fF
C555 w_756_1172# a_762_1127# 0.12fF
C556 a_3358_75# s1 0.72fF
C557 a_726_356# gnd 0.21fF
C558 a_759_3032# a_759_2988# 0.21fF
C559 w_102_2736# a4 0.10fF
C560 p3 a_96_2083# 0.10fF
C561 a_3410_43# gnd 0.10fF
C562 w_34_629# a1 0.09fF
C563 w_70_2566# b4 0.09fF
C564 p2 w_743_2705# 0.14fF
C565 c4 a_1085_1885# 0.47fF
C566 a_83_2572# a_751_2471# 0.54fF
C567 p1 a_762_1127# 0.15fF
C568 w_34_629# a_47_635# 0.02fF
C569 w_748_2142# vdd 0.14fF
C570 a0 2XOR_0/a_125_49# 0.12fF
C571 a_96_2115# vdd 0.49fF
C572 gnd a_3358_n373# 0.08fF
C573 p2 a_751_2471# 0.15fF
C574 a_720_432# a_751_2471# 0.25fF
C575 w_3349_445# a_3362_453# 0.05fF
C576 a_764_2650# a_772_2650# 0.41fF
C577 inverter1_6/w_n19_78# a_3408_488# 0.05fF
C578 p1 a_47_635# 0.17fF
C579 a_56_2664# a_115_2744# 0.12fF
C580 a_3421_2429# a_3409_2500# 0.17fF
C581 p1 a_726_400# 0.08fF
C582 a_3404_110# s1 0.08fF
C583 a_79_807# vdd 0.49fF
C584 w_3397_67# a_3358_75# 0.14fF
C585 w_753_1700# vdd 0.09fF
C586 gnd 2NAND1_0/a_3_n40# 0.21fF
C587 w_748_2142# a_165_1251# 0.09fF
C588 a_766_2471# a_774_2471# 0.52fF
C589 a_179_1919# a_64_1943# 0.12fF
C590 a_824_400# vdd 0.68fF
C591 a_3421_2429# gnd 0.18fF
C592 a_3358_n373# s0 0.72fF
C593 a_774_1645# a_782_1645# 0.41fF
C594 p2 a_762_1127# 0.15fF
C595 a_932_1072# a_775_1022# 0.15fF
C596 a_720_432# a_762_1127# 0.08fF
C597 p4 w_745_2535# 0.12fF
C598 c5 a_1052_2722# 0.05fF
C599 a_3409_2500# s4 0.08fF
C600 p4 a_752_2825# 0.15fF
C601 a3 a_36_2118# 0.12fF
C602 a_3404_110# w_3397_67# 0.10fF
C603 p4 a_55_2747# 0.08fF
C604 w_21_2061# b3 0.06fF
C605 w_83_2107# a_96_2115# 0.05fF
C606 a_37_2035# a_96_2115# 0.12fF
C607 inverter1_1/w_n19_78# c4 0.06fF
C608 a_3404_110# p1 0.09fF
C609 s4 gnd 0.05fF
C610 p1 w_3345_67# 0.10fF
C611 a_22_1450# b2 0.00fF
C612 a_3408_488# a_3362_453# 0.51fF
C613 p4 a_115_2712# 0.10fF
C614 w_3_836# vdd 0.12fF
C615 a_761_2148# a_761_1890# 1.59fF
C616 2XOR_0/w_118_6# p0 0.03fF
C617 a_3393_1607# gnd 0.10fF
C618 vdd 2NAND1_0/w_n10_n2# 0.22fF
C619 a_3404_n338# w_3345_n381# 0.07fF
C620 a_749_2650# gnd 0.25fF
C621 a_720_432# a_3358_75# 0.08fF
C622 a_50_1275# a_775_1022# 0.41fF
C623 a_3408_488# gnd 0.37fF
C624 a_3439_1674# vdd 0.21fF
C625 p0 vdd 0.41fF
C626 a_751_2471# a_758_2471# 0.57fF
C627 w_753_1700# a_759_1645# 0.21fF
C628 w_1023_2786# vdd 0.14fF
C629 a0 2NAND1_0/w_n10_n2# 0.09fF
C630 b1 a_79_807# 0.08fF
C631 b3 gnd 0.22fF
C632 a_23_1367# gnd 0.18fF
C633 a_64_1943# gnd 0.09fF
C634 w_746_3026# a_179_1919# 0.09fF
C635 a_1052_2722# a_1060_2722# 0.52fF
C636 a_720_432# a_3404_110# 0.00fF
C637 a_720_432# w_3345_67# 0.10fF
C638 a_775_1022# gnd 0.13fF
C639 w_182_2574# vdd 0.13fF
C640 a_165_1251# vdd 0.44fF
C641 a_19_810# gnd 0.37fF
C642 w_39_2773# a_55_2747# 0.05fF
C643 w_7_1393# a_23_1367# 0.05fF
C644 w_121_1439# a_82_1447# 0.14fF
C645 w_37_1269# b2 0.09fF
C646 a0 vdd 0.75fF
C647 a4 vdd 0.75fF
C648 a_47_591# gnd 0.21fF
C649 a_162_611# vdd 0.74fF
C650 a_1093_1885# a_1101_1885# 0.41fF
C651 a_179_1919# a_759_3032# 0.08fF
C652 a_3362_421# gnd 0.10fF
C653 p3 w_748_2142# 0.09fF
C654 p3 a_96_2115# 0.72fF
C655 s1 gnd 0.05fF
C656 a_179_1919# a_83_2572# 0.05fF
C657 w_66_799# a_19_810# 0.07fF
C658 w_40_2690# b4 0.06fF
C659 w_154_2736# a_56_2664# 0.10fF
C660 w_102_2736# a_115_2744# 0.05fF
C661 p1 a_50_1275# 0.10fF
C662 a_752_2825# a_749_2650# 1.54fF
C663 w_83_2107# vdd 0.12fF
C664 a_37_2035# vdd 0.21fF
C665 a_772_2650# gnd 0.41fF
C666 a_83_2572# b4 0.08fF
C667 a_751_2471# c5 0.15fF
C668 a_165_1251# a_162_611# 0.15fF
C669 w_811_394# a_47_635# 0.09fF
C670 p3 w_753_1700# 0.14fF
C671 w_1072_1940# vdd 0.09fF
C672 a_82_1447# vdd 0.49fF
C673 a_756_2650# a_764_2650# 0.41fF
C674 a_759_1645# vdd 1.10fF
C675 inverter1_6/w_n19_78# p2 0.07fF
C676 p1 a_79_775# 0.10fF
C677 a_932_1072# p2 0.01fF
C678 b4 a_56_2664# 0.04fF
C679 inverter1_3/w_n19_78# a_3451_1603# 0.05fF
C680 a_720_432# a_932_1072# 0.10fF
C681 c4 a_3409_2500# 0.00fF
C682 w_811_394# a_726_400# 0.09fF
C683 a_782_1645# gnd 0.41fF
C684 b1 vdd 0.46fF
C685 gnd m1_48_33# 0.09fF
C686 a_758_2471# a_766_2471# 0.52fF
C687 2XOR_0/a_137_n22# gnd 0.18fF
C688 a_3416_39# s1 0.13fF
C689 inverter1_2/w_n19_78# vdd 0.12fF
C690 c4 gnd 0.19fF
C691 p1 gnd 0.36fF
C692 a_3409_2500# a_3363_2465# 0.51fF
C693 c5 a_1044_2722# 0.05fF
C694 a_766_1645# a_774_1645# 0.41fF
C695 p2 a_50_1275# 0.06fF
C696 a_162_611# a_759_1645# 0.11fF
C697 a_720_432# a_50_1275# 0.19fF
C698 2XOR_0/inverter1_1/w_n19_78# 2XOR_0/a_137_n22# 0.05fF
C699 a_198_2548# vdd 0.21fF
C700 p4 a_749_2650# 0.15fF
C701 a_36_2118# a_96_2115# 0.51fF
C702 w_6_1476# vdd 0.12fF
C703 a2 a_22_1450# 0.12fF
C704 p1 w_713_394# 0.09fF
C705 a_3416_39# w_3397_67# 0.10fF
C706 p3 a_3439_1674# 0.12fF
C707 a_759_3032# gnd 0.22fF
C708 w_926_1117# vdd 0.11fF
C709 2XOR_0/w_66_6# 2XOR_0/a_79_14# 0.05fF
C710 a_3409_2500# w_3402_2457# 0.10fF
C711 p0 w_3345_n381# 0.10fF
C712 w_755_1935# a_761_1890# 0.12fF
C713 w_1072_1940# a_759_1645# 0.14fF
C714 a_83_2572# gnd 0.28fF
C715 a_3416_n409# a_3404_n338# 0.17fF
C716 w_146_637# vdd 0.13fF
C717 w_182_2574# a_198_2548# 0.05fF
C718 a_64_1943# a_761_1890# 0.09fF
C719 p1 inverter1_8/w_n19_78# 0.07fF
C720 a_50_1275# a_50_1231# 0.21fF
C721 a_3410_n405# gnd 0.01fF
C722 a_3358_n405# gnd 0.01fF
C723 s0 gnd 0.16fF
C724 a_3358_n373# gnd 0.08fF
C725 vdd gnd 159.42fF
C726 gnd gnd 10.33fF
C727 a_3410_43# gnd 0.01fF
C728 a_3358_43# gnd 0.01fF
C729 s1 gnd 0.13fF
C730 a_3358_75# gnd 0.01fF
C731 a_824_356# gnd 0.01fF
C732 a_726_356# gnd 0.01fF
C733 a_3414_421# gnd 0.01fF
C734 a_3362_421# gnd 0.01fF
C735 a_726_400# gnd 0.88fF
C736 s2 gnd 0.16fF
C737 a_47_591# gnd 0.01fF
C738 a_47_635# gnd 4.64fF
C739 a_131_775# gnd 0.01fF
C740 a_79_775# gnd 0.01fF
C741 a_79_807# gnd 0.04fF
C742 a_20_727# gnd 1.15fF
C743 b1 gnd 9.40fF
C744 a_19_810# gnd 0.90fF
C745 a1 gnd 0.19fF
C746 a_775_978# gnd 0.01fF
C747 a_947_1072# gnd 0.01fF
C748 a_939_1072# gnd 0.01fF
C749 a_777_1127# gnd 0.01fF
C750 a_769_1127# gnd 0.01fF
C751 a_775_1022# gnd 3.89fF
C752 a_762_1127# gnd 2.58fF
C753 a_50_1231# gnd 0.01fF
C754 a_50_1275# gnd 4.47fF
C755 a_134_1415# gnd 0.01fF
C756 a_82_1415# gnd 0.01fF
C757 a_82_1447# gnd 0.11fF
C758 a_23_1367# gnd 1.15fF
C759 b2 gnd 9.55fF
C760 a_22_1450# gnd 1.92fF
C761 a2 gnd 6.79fF
C762 a_3445_1607# gnd 0.01fF
C763 a_3393_1607# gnd 0.01fF
C764 s3 gnd 2.06fF
C765 a_3393_1639# gnd 0.11fF
C766 a_782_1645# gnd 0.01fF
C767 a_774_1645# gnd 0.01fF
C768 a_766_1645# gnd 0.01fF
C769 a_1101_1885# gnd 0.01fF
C770 a_1093_1885# gnd 0.01fF
C771 a_1085_1885# gnd 0.01fF
C772 a_776_1890# gnd 0.01fF
C773 a_768_1890# gnd 0.01fF
C774 a_64_1899# gnd 0.01fF
C775 a_761_1890# gnd 2.47fF
C776 a_759_1645# gnd 3.13fF
C777 a_64_1943# gnd 12.72fF
C778 a_148_2083# gnd 0.01fF
C779 a_761_2104# gnd 0.01fF
C780 a_761_2148# gnd 1.86fF
C781 a_37_2035# gnd 1.15fF
C782 b3 gnd 9.79fF
C783 a_36_2118# gnd 0.78fF
C784 a3 gnd 0.20fF
C785 a_3415_2433# gnd 0.01fF
C786 a_3363_2433# gnd 0.01fF
C787 s4 gnd 0.16fF
C788 a_782_2471# gnd 0.01fF
C789 a_774_2471# gnd 0.01fF
C790 a_766_2471# gnd 0.01fF
C791 a_758_2471# gnd 0.01fF
C792 a_83_2528# gnd 0.01fF
C793 a_198_2548# gnd 0.13fF
C794 a_772_2650# gnd 0.01fF
C795 a_764_2650# gnd 0.01fF
C796 a_756_2650# gnd 0.01fF
C797 a_1060_2722# gnd 0.01fF
C798 a_1052_2722# gnd 0.01fF
C799 a_1044_2722# gnd 0.01fF
C800 a_1036_2722# gnd 0.01fF
C801 a_167_2712# gnd 0.01fF
C802 a_115_2712# gnd 0.01fF
C803 a_162_611# gnd 5.28fF
C804 a_115_2744# gnd 0.11fF
C805 a_56_2664# gnd 1.15fF
C806 b4 gnd 10.21fF
C807 c5 gnd 6.47fF
C808 a_55_2747# gnd 1.92fF
C809 a4 gnd 7.53fF
C810 a_749_2650# gnd 2.60fF
C811 a_751_2471# gnd 2.92fF
C812 a_83_2572# gnd 6.47fF
C813 a_767_2825# gnd 0.01fF
C814 a_759_2825# gnd 0.01fF
C815 a_752_2825# gnd 2.26fF
C816 a_165_1251# gnd 8.76fF
C817 a_759_2988# gnd 0.01fF
C818 a_759_3032# gnd 1.87fF
C819 a_179_1919# gnd 2.68fF
C820 w_3397_n381# gnd 1.16fF
C821 w_3345_n381# gnd 1.16fF
C822 w_3397_67# gnd 1.16fF
C823 w_811_394# gnd 1.09fF
C824 w_713_394# gnd 1.06fF
C825 w_3401_445# gnd 1.16fF
C826 w_3349_445# gnd 0.45fF
C827 w_146_637# gnd 1.03fF
C828 w_34_629# gnd 1.09fF
C829 w_4_753# gnd 1.03fF
C830 w_118_799# gnd 1.16fF
C831 w_66_799# gnd 1.16fF
C832 w_3_836# gnd 1.03fF
C833 w_762_1016# gnd 1.09fF
C834 w_926_1117# gnd 1.61fF
C835 w_756_1172# gnd 1.61fF
C836 w_149_1277# gnd 1.03fF
C837 w_37_1269# gnd 1.09fF
C838 w_7_1393# gnd 1.03fF
C839 w_121_1439# gnd 1.16fF
C840 w_69_1439# gnd 1.16fF
C841 w_6_1476# gnd 1.03fF
C842 w_3432_1631# gnd 1.16fF
C843 w_3380_1631# gnd 1.16fF
C844 w_753_1700# gnd 2.07fF
C845 w_1072_1940# gnd 2.07fF
C846 w_755_1935# gnd 1.61fF
C847 w_163_1945# gnd 1.03fF
C848 w_51_1937# gnd 1.09fF
C849 w_21_2061# gnd 1.03fF
C850 w_748_2142# gnd 1.09fF
C851 w_135_2107# gnd 1.16fF
C852 w_83_2107# gnd 0.80fF
C853 w_20_2144# gnd 1.03fF
C854 w_3402_2457# gnd 1.16fF
C855 w_745_2535# gnd 2.19fF
C856 w_182_2574# gnd 1.03fF
C857 w_70_2566# gnd 1.09fF
C858 w_743_2705# gnd 2.07fF
C859 w_40_2690# gnd 1.03fF
C860 w_154_2736# gnd 1.16fF
C861 w_102_2736# gnd 1.16fF
C862 w_1023_2786# gnd 2.19fF
C863 w_39_2773# gnd 1.03fF
C864 w_746_2870# gnd 1.61fF
C865 w_746_3026# gnd 1.09fF
C866 a_3404_n338# gnd 1.97fF
C867 p0 gnd 0.73fF
C868 inverter1_10/w_n19_78# gnd 1.03fF
C869 a_3416_n409# gnd 1.16fF
C870 inverter1_9/w_n19_78# gnd 1.03fF
C871 a_3404_110# gnd 1.97fF
C872 p1 gnd 0.29fF
C873 inverter1_8/w_n19_78# gnd 1.03fF
C874 2XOR_0/a_131_n18# gnd 0.01fF
C875 2XOR_0/a_79_n18# gnd 0.01fF
C876 2XOR_0/a_79_14# gnd 0.11fF
C877 2XOR_0/w_118_6# gnd 1.16fF
C878 2XOR_0/w_66_6# gnd 1.16fF
C879 2XOR_0/a_137_n22# gnd 1.16fF
C880 b0 gnd 9.21fF
C881 2XOR_0/inverter1_1/w_n19_78# gnd 1.03fF
C882 2XOR_0/a_125_49# gnd 1.97fF
C883 a0 gnd 6.31fF
C884 2XOR_0/inverter1_0/w_n19_78# gnd 1.03fF
C885 a_3416_39# gnd 1.16fF
C886 inverter1_7/w_n19_78# gnd 1.03fF
C887 a_3408_488# gnd 1.97fF
C888 p2 gnd 0.26fF
C889 inverter1_6/w_n19_78# gnd 1.03fF
C890 a_3420_417# gnd 1.16fF
C891 a_824_400# gnd 12.22fF
C892 inverter1_5/w_n19_78# gnd 1.03fF
C893 a_3439_1674# gnd 1.97fF
C894 p3 gnd 0.37fF
C895 inverter1_4/w_n19_78# gnd 1.03fF
C896 a_3451_1603# gnd 1.16fF
C897 a_932_1072# gnd 0.45fF
C898 inverter1_3/w_n19_78# gnd 1.03fF
C899 a_3409_2500# gnd 1.97fF
C900 p4 gnd 47.46fF
C901 inverter1_2/w_n19_78# gnd 1.03fF
C902 a_3421_2429# gnd 1.16fF
C903 c4 gnd 12.78fF
C904 inverter1_1/w_n19_78# gnd 1.03fF
C905 a_720_432# gnd 86.89fF
C906 inverter1_0/w_n19_78# gnd 1.03fF
C907 2NAND1_0/a_3_n40# gnd 0.01fF
C908 m1_48_33# gnd 0.79fF
C909 2NAND1_0/w_n10_n2# gnd 1.09fF

.control
tran 0.01n 100n
 plot v(a0) v(a1)+2 v(a2)+4 v(a3)+6 v(a4)+8
 plot v(b0) v(b1)+2 v(b2)+4 v(b3)+6 v(b4)+8
 plot v(s0) v(s1)+2 v(s2)+4 v(s3)+6 v(s4)+8
 plot v(c5)

meas tran t_b0_50_rise  WHEN v(b0)=0.9 RISE=1
meas tran t_cout_50_rise  WHEN v(c5)=0.9 RISE=1

meas tran t_b0_50_fall  WHEN v(b0)=0.9 FALL=1
meas tran t_cout_50_fall  WHEN v(c5)=0.9 FALL=1

let Rise_delay  = t_cout_50_rise - t_b0_50_rise
let Fall_delay  = t_cout_50_fall - t_b0_50_fall

print Rise_delay
print FALL_delay

run
.endc

.end

* t_b0_50_rise        =  2.005000e-08
* t_s4_50_rise        =  2.069641e-08
* t_b0_50_fall        =  2.515000e-08
* t_s4_50_fall        =  2.581268e-08
* Propagation delay results:
* Rise delay  = t_s4_50_rise - t_b0_50_rise = 664.10 psec
* Fall delay  = t_s4_50_fall - t_b0_50_fall = 661.27 psec
