**5-bit Carry Lookahead Adder
.include TSMC_180nm.txt
.param SUPPLY=1.8
.global gnd vdd
.param LAMBDA=0.09u
.param width_N=0.9u
.param width_P=2*width_N

VDD vdd gnd 1.8

* Va0 a0 gnd PULSE(0 0 20n 0 0 100n 200n)
* Va1 a1 gnd PULSE(0 0 20n 0 0 100n 200n)
* Va2 a2 gnd PULSE(0 0 20n 0 0 100n 200n)
* Va3 a3 gnd PULSE(0 0 20n 0 0 100n 200n)
* Va4 a4 gnd PULSE(0 1.8 20n 0 0 100n 200n)

* Vb0 b0 gnd PULSE(0 0 0 20n 0 100n 200n)
* Vb1 b1 gnd PULSE(0 0 20n 0 0 100n 200n)
* Vb2 b2 gnd PULSE(0 0 0 20n 0 100n 200n)
* Vb3 b3 gnd PULSE(0 0 0 20n 0 100n 200n)
* Vb4 b4 gnd PULSE(0 1.8 20n 0 0 100n 200n)

Va0 a0 gnd 1.8
Va1 a1 gnd 1.8
Va2 a2 gnd 1.8
Va3 a3 gnd 1.8
Va4 a4 gnd 1.8

Vb0 b0 gnd 0
Vb1 b1 gnd 0
Vb2 b2 gnd 0
Vb3 b3 gnd 0
Vb4 b4 gnd PULSE(0 1.8 20n 0 0 5n 10n)

Vclk clk gnd PULSE(0 1.8 20n 0 0 3n 6n)
* SPICE3 file created from fullcir1.ext - technology:

* SPICE3 file created from finalckt.ext - technology: scmos

.option scale=0.09u

M1000 2NAND1_0/out 2XOR_0/a vdd 2NAND1_0/w_n10_n2# CMOSP w=20 l=2
+  ad=120 pd=52 as=13315 ps=6035
M1001 2NAND1_0/out 2XOR_0/b 2NAND1_0/a_3_n40# Gnd CMOSN w=20 l=2
+  ad=100 pd=50 as=120 ps=52
M1002 2NAND1_0/a_3_n40# 2XOR_0/a gnd Gnd CMOSN w=20 l=2
+  ad=0 pd=0 as=8042 ps=4052
M1003 vdd 2XOR_0/b 2NAND1_0/out 2NAND1_0/w_n10_n2# CMOSP w=20 l=2
+  ad=0 pd=0 as=0 ps=0
M1004 a_720_432# 2NAND1_0/out gnd Gnd CMOSN w=10 l=2
+  ad=70 pd=34 as=0 ps=0
M1005 a_720_432# 2NAND1_0/out vdd inverter1_0/w_n19_78# CMOSP w=20 l=2
+  ad=140 pd=54 as=0 ps=0
M1006 a_3421_2429# c4 gnd Gnd CMOSN w=10 l=2
+  ad=70 pd=34 as=0 ps=0
M1007 a_3421_2429# c4 vdd inverter1_1/w_n19_78# CMOSP w=20 l=2
+  ad=140 pd=54 as=0 ps=0
M1008 a_3409_2500# p4 gnd Gnd CMOSN w=10 l=2
+  ad=70 pd=34 as=0 ps=0
M1009 a_3409_2500# p4 vdd inverter1_2/w_n19_78# CMOSP w=20 l=2
+  ad=140 pd=54 as=0 ps=0
M1010 a_3451_1603# a_932_1072# gnd Gnd CMOSN w=10 l=2
+  ad=70 pd=34 as=0 ps=0
M1011 a_3451_1603# a_932_1072# vdd inverter1_3/w_n19_78# CMOSP w=20 l=2
+  ad=140 pd=54 as=0 ps=0
M1012 a_3439_1674# p3 gnd Gnd CMOSN w=10 l=2
+  ad=70 pd=34 as=0 ps=0
M1013 a_3439_1674# p3 vdd inverter1_4/w_n19_78# CMOSP w=20 l=2
+  ad=140 pd=54 as=0 ps=0
M1014 a_3420_417# a_824_400# gnd Gnd CMOSN w=10 l=2
+  ad=70 pd=34 as=0 ps=0
M1015 a_3420_417# a_824_400# vdd inverter1_5/w_n19_78# CMOSP w=20 l=2
+  ad=140 pd=54 as=0 ps=0
M1016 a_3408_488# p2 gnd Gnd CMOSN w=10 l=2
+  ad=70 pd=34 as=0 ps=0
M1017 a_3408_488# p2 vdd inverter1_6/w_n19_78# CMOSP w=20 l=2
+  ad=140 pd=54 as=0 ps=0
M1018 a_3416_39# a_720_432# gnd Gnd CMOSN w=10 l=2
+  ad=70 pd=34 as=0 ps=0
M1019 a_3416_39# a_720_432# vdd inverter1_7/w_n19_78# CMOSP w=20 l=2
+  ad=140 pd=54 as=0 ps=0
M1020 2XOR_0/a_125_49# 2XOR_0/a gnd Gnd CMOSN w=10 l=2
+  ad=70 pd=34 as=0 ps=0
M1021 2XOR_0/a_125_49# 2XOR_0/a vdd 2XOR_0/inverter1_0/w_n19_78# CMOSP w=20 l=2
+  ad=140 pd=54 as=0 ps=0
M1022 2XOR_0/a_137_n22# 2XOR_0/b gnd Gnd CMOSN w=10 l=2
+  ad=70 pd=34 as=0 ps=0
M1023 2XOR_0/a_137_n22# 2XOR_0/b vdd 2XOR_0/inverter1_1/w_n19_78# CMOSP w=20 l=2
+  ad=140 pd=54 as=0 ps=0
M1024 p0 2XOR_0/a_125_49# 2XOR_0/a_79_14# 2XOR_0/w_118_6# CMOSP w=20 l=2
+  ad=120 pd=52 as=320 ps=152
M1025 2XOR_0/a_79_14# 2XOR_0/a vdd 2XOR_0/w_66_6# CMOSP w=20 l=2
+  ad=0 pd=0 as=0 ps=0
M1026 2XOR_0/a_79_n18# 2XOR_0/a gnd Gnd CMOSN w=10 l=2
+  ad=60 pd=32 as=0 ps=0
M1027 2XOR_0/a_131_n18# 2XOR_0/a_125_49# p0 Gnd CMOSN w=10 l=2
+  ad=60 pd=32 as=100 ps=60
M1028 2XOR_0/a_79_14# 2XOR_0/a_137_n22# p0 2XOR_0/w_118_6# CMOSP w=20 l=2
+  ad=0 pd=0 as=0 ps=0
M1029 vdd 2XOR_0/b 2XOR_0/a_79_14# 2XOR_0/w_66_6# CMOSP w=20 l=2
+  ad=0 pd=0 as=0 ps=0
M1030 p0 2XOR_0/b 2XOR_0/a_79_n18# Gnd CMOSN w=10 l=2
+  ad=0 pd=0 as=0 ps=0
M1031 gnd 2XOR_0/a_137_n22# 2XOR_0/a_131_n18# Gnd CMOSN w=10 l=2
+  ad=0 pd=0 as=0 ps=0
M1032 a_3404_110# p1 gnd Gnd CMOSN w=10 l=2
+  ad=70 pd=34 as=0 ps=0
M1033 a_3404_110# p1 vdd inverter1_8/w_n19_78# CMOSP w=20 l=2
+  ad=140 pd=54 as=0 ps=0
M1034 a_3416_n409# gnd gnd Gnd CMOSN w=10 l=2
+  ad=70 pd=34 as=0 ps=0
M1035 a_3416_n409# gnd vdd inverter1_9/w_n19_78# CMOSP w=20 l=2
+  ad=140 pd=54 as=0 ps=0
M1036 a_3404_n338# p0 gnd Gnd CMOSN w=10 l=2
+  ad=70 pd=34 as=0 ps=0
M1037 a_3404_n338# p0 vdd inverter1_10/w_n19_78# CMOSP w=20 l=2
+  ad=140 pd=54 as=0 ps=0
M1038 2XOR_0/b a_n746_61# gnd Gnd CMOSN w=10 l=2
+  ad=70 pd=34 as=0 ps=0
M1039 2XOR_0/b a_n746_61# vdd inverter1_11/w_n19_78# CMOSP w=20 l=2
+  ad=140 pd=54 as=0 ps=0
M1040 a_759_3032# a_179_1919# a_759_2988# Gnd CMOSN w=20 l=2
+  ad=100 pd=50 as=120 ps=52
M1041 vdd a_64_1943# c4 w_1072_1940# CMOSP w=20 l=2
+  ad=0 pd=0 as=320 ps=152
M1042 s3 a_932_1072# a_3393_1607# Gnd CMOSN w=10 l=2
+  ad=100 pd=60 as=60 ps=32
M1043 gnd a_759_3032# a_1060_2722# Gnd CMOSN w=50 l=2
+  ad=0 pd=0 as=300 ps=112
M1044 a_n847_2598# a4 vdd w_n860_2590# CMOSP w=40 l=2
+  ad=240 pd=92 as=0 ps=0
M1045 a_n638_2176# a_n704_2213# vdd w_n654_2202# CMOSP w=20 l=2
+  ad=140 pd=54 as=0 ps=0
M1046 a_777_1127# p2 a_769_1127# Gnd CMOSN w=30 l=2
+  ad=180 pd=72 as=180 ps=72
M1047 a_3362_453# p2 vdd w_3349_445# CMOSP w=20 l=2
+  ad=320 pd=152 as=0 ps=0
M1048 a_131_775# a_19_810# p1 Gnd CMOSN w=10 l=2
+  ad=60 pd=32 as=51 ps=31
M1049 c5 a_749_2650# vdd w_1023_2786# CMOSP w=20 l=2
+  ad=340 pd=154 as=0 ps=0
M1050 a_756_2650# p4 a_749_2650# Gnd CMOSN w=40 l=2
+  ad=240 pd=92 as=200 ps=90
M1051 a_761_2104# p3 gnd Gnd CMOSN w=20 l=2
+  ad=120 pd=52 as=0 ps=0
M1052 gnd a_3416_n409# a_3410_n405# Gnd CMOSN w=10 l=2
+  ad=0 pd=0 as=60 ps=32
M1053 a_47_591# a_n661_842# gnd Gnd CMOSN w=20 l=2
+  ad=120 pd=52 as=0 ps=0
M1054 a_1052_2722# a_749_2650# a_1044_2722# Gnd CMOSN w=50 l=2
+  ad=300 pd=112 as=300 ps=112
M1055 a_3410_43# a_3404_110# s1 Gnd CMOSN w=10 l=2
+  ad=60 pd=32 as=100 ps=60
M1056 a_n882_43# a0 vdd w_n895_35# CMOSP w=40 l=2
+  ad=240 pd=92 as=0 ps=0
M1057 a_776_1890# p2 a_768_1890# Gnd CMOSN w=30 l=2
+  ad=180 pd=72 as=180 ps=72
M1058 s3 a_3439_1674# a_3393_1639# w_3432_1631# CMOSP w=20 l=2
+  ad=120 pd=52 as=320 ps=152
M1059 a_n844_1467# clk a_n844_1505# w_n857_1497# CMOSP w=40 l=2
+  ad=200 pd=90 as=240 ps=92
M1060 a_n784_2855# clk vdd w_n797_2847# CMOSP w=20 l=2
+  ad=100 pd=50 as=0 ps=0
M1061 a_n704_2213# a_n772_2213# vdd w_n717_2205# CMOSP w=20 l=2
+  ad=100 pd=50 as=0 ps=0
M1062 gnd a_761_2148# a_1101_1885# Gnd CMOSN w=40 l=2
+  ad=0 pd=0 as=240 ps=92
M1063 a_n843_1241# clk a_n843_1279# w_n856_1271# CMOSP w=40 l=2
+  ad=200 pd=90 as=240 ps=92
M1064 a_n746_61# a_n814_61# vdd w_n759_53# CMOSP w=20 l=2
+  ad=100 pd=50 as=0 ps=0
M1065 a_782_1645# p1 a_774_1645# Gnd CMOSN w=40 l=2
+  ad=240 pd=92 as=240 ps=92
M1066 a_82_1415# a_n642_1486# gnd Gnd CMOSN w=10 l=2
+  ad=60 pd=32 as=0 ps=0
M1067 a_19_810# a_n661_842# gnd Gnd CMOSN w=10 l=2
+  ad=70 pd=34 as=0 ps=0
M1068 a_n840_2157# b3 gnd Gnd CMOSN w=10 l=2
+  ad=50 pd=30 as=0 ps=0
M1069 a_761_1890# p2 vdd w_755_1935# CMOSP w=20 l=2
+  ad=220 pd=102 as=0 ps=0
M1070 s1 a_720_432# a_3358_43# Gnd CMOSN w=10 l=2
+  ad=0 pd=0 as=60 ps=32
M1071 a_n776_1523# a_n844_1467# a_n776_1469# Gnd CMOSN w=20 l=2
+  ad=100 pd=50 as=120 ps=52
M1072 a_115_2744# a_56_2664# p4 w_154_2736# CMOSP w=20 l=2
+  ad=320 pd=152 as=120 ps=52
M1073 a_n642_1948# a_n708_1985# vdd w_n658_1974# CMOSP w=20 l=2
+  ad=140 pd=54 as=0 ps=0
M1074 vdd a_720_432# a_762_1127# w_756_1172# CMOSP w=20 l=2
+  ad=0 pd=0 as=220 ps=102
M1075 a_n661_842# a_n727_879# gnd Gnd CMOSN w=10 l=2
+  ad=70 pd=34 as=0 ps=0
M1076 a_96_2115# a_37_2035# p3 w_135_2107# CMOSP w=20 l=2
+  ad=320 pd=152 as=120 ps=52
M1077 out in gnd Gnd CMOSN w=10 l=2
+  ad=70 pd=34 as=0 ps=0
M1078 vdd a_932_1072# a_3393_1639# w_3380_1631# CMOSP w=20 l=2
+  ad=0 pd=0 as=0 ps=0
M1079 a_n843_1241# a2 gnd Gnd CMOSN w=10 l=2
+  ad=50 pd=30 as=0 ps=0
M1080 a_n746_7# a_n814_61# gnd Gnd CMOSN w=20 l=2
+  ad=120 pd=52 as=0 ps=0
M1081 a_79_807# a_n661_842# vdd w_66_799# CMOSP w=20 l=2
+  ad=320 pd=152 as=0 ps=0
M1082 a_64_1899# a_n638_2176# gnd Gnd CMOSN w=20 l=2
+  ad=120 pd=52 as=0 ps=0
M1083 a_3358_n405# p0 gnd Gnd CMOSN w=10 l=2
+  ad=60 pd=32 as=0 ps=0
M1084 a_n727_879# a_n795_879# vdd w_n740_871# CMOSP w=20 l=2
+  ad=100 pd=50 as=0 ps=0
M1085 a_n784_2801# clk gnd Gnd CMOSN w=20 l=2
+  ad=120 pd=52 as=0 ps=0
M1086 2XOR_0/a a_n751_296# vdd w_n701_285# CMOSP w=20 l=2
+  ad=140 pd=54 as=0 ps=0
M1087 p1 a_n673_636# a_79_775# Gnd CMOSN w=10 l=2
+  ad=0 pd=0 as=60 ps=32
M1088 gnd a_165_1251# a_767_2825# Gnd CMOSN w=30 l=2
+  ad=0 pd=0 as=180 ps=72
M1089 a_n840_2195# b3 vdd w_n853_2187# CMOSP w=40 l=2
+  ad=240 pd=92 as=0 ps=0
M1090 a_n708_1985# clk a_n708_1931# Gnd CMOSN w=20 l=2
+  ad=100 pd=50 as=120 ps=52
M1091 a_n716_2855# a_n784_2855# vdd w_n729_2847# CMOSP w=20 l=2
+  ad=100 pd=50 as=0 ps=0
M1092 a_64_1943# a_n638_2176# vdd w_51_1937# CMOSP w=20 l=2
+  ad=120 pd=52 as=0 ps=0
M1093 a_n814_61# a_n882_5# a_n814_7# Gnd CMOSN w=20 l=2
+  ad=100 pd=50 as=120 ps=52
M1094 a_n776_1523# clk vdd w_n789_1515# CMOSP w=20 l=2
+  ad=100 pd=50 as=0 ps=0
M1095 a_n751_296# clk a_n751_242# Gnd CMOSN w=20 l=2
+  ad=100 pd=50 as=120 ps=52
M1096 s1 a_3404_110# a_3358_75# w_3397_67# CMOSP w=20 l=2
+  ad=120 pd=52 as=320 ps=152
M1097 a_3358_n373# a_3416_n409# s0 w_3397_n381# CMOSP w=20 l=2
+  ad=320 pd=152 as=120 ps=52
M1098 a_n814_61# clk vdd w_n827_53# CMOSP w=20 l=2
+  ad=100 pd=50 as=0 ps=0
M1099 vdd p4 a_752_2825# w_746_2870# CMOSP w=20 l=2
+  ad=0 pd=0 as=220 ps=102
M1100 a_n852_2799# b4 gnd Gnd CMOSN w=10 l=2
+  ad=50 pd=30 as=0 ps=0
M1101 a_3415_2433# a_3409_2500# s4 Gnd CMOSN w=10 l=2
+  ad=60 pd=32 as=100 ps=60
M1102 a_n775_1297# clk vdd w_n788_1289# CMOSP w=20 l=2
+  ad=100 pd=50 as=0 ps=0
M1103 a_759_3032# p4 vdd w_746_3026# CMOSP w=20 l=2
+  ad=120 pd=52 as=0 ps=0
M1104 p1 a_19_810# a_79_807# w_118_799# CMOSP w=20 l=2
+  ad=120 pd=52 as=0 ps=0
M1105 a_n642_1948# a_n708_1985# gnd Gnd CMOSN w=10 l=2
+  ad=70 pd=34 as=0 ps=0
M1106 vdd a_162_611# a_775_1022# w_762_1016# CMOSP w=20 l=2
+  ad=0 pd=0 as=120 ps=52
M1107 a_82_1447# a_n642_1486# vdd w_69_1439# CMOSP w=20 l=2
+  ad=320 pd=152 as=0 ps=0
M1108 gnd a_20_727# a_131_775# Gnd CMOSN w=10 l=2
+  ad=0 pd=0 as=0 ps=0
M1109 a_19_810# a_n661_842# vdd w_3_836# CMOSP w=20 l=2
+  ad=140 pd=54 as=0 ps=0
M1110 a_n727_825# a_n795_879# gnd Gnd CMOSN w=20 l=2
+  ad=120 pd=52 as=0 ps=0
M1111 a_939_1072# a_50_1275# a_932_1072# Gnd CMOSN w=30 l=2
+  ad=180 pd=72 as=150 ps=70
M1112 vdd a_720_432# a_3358_75# w_3345_67# CMOSP w=20 l=2
+  ad=0 pd=0 as=0 ps=0
M1113 a_162_611# a_47_635# gnd Gnd CMOSN w=10 l=2
+  ad=70 pd=34 as=0 ps=0
M1114 a_n779_2616# a_n847_2560# a_n779_2562# Gnd CMOSN w=20 l=2
+  ad=100 pd=50 as=120 ps=52
M1115 gnd p1 a_782_2471# Gnd CMOSN w=50 l=2
+  ad=0 pd=0 as=300 ps=112
M1116 a_n772_2159# clk gnd Gnd CMOSN w=20 l=2
+  ad=120 pd=52 as=0 ps=0
M1117 a_761_2148# p3 vdd w_748_2142# CMOSP w=20 l=2
+  ad=120 pd=52 as=0 ps=0
M1118 a_47_635# a_n673_636# a_47_591# Gnd CMOSN w=20 l=2
+  ad=100 pd=50 as=0 ps=0
M1119 a_134_1415# a_22_1450# p2 Gnd CMOSN w=10 l=2
+  ad=60 pd=32 as=100 ps=60
M1120 2XOR_0/a a_n751_296# gnd Gnd CMOSN w=10 l=2
+  ad=70 pd=34 as=0 ps=0
M1121 a_n661_842# a_n727_879# vdd w_n677_868# CMOSP w=20 l=2
+  ad=140 pd=54 as=0 ps=0
M1122 a_n716_2801# a_n784_2855# gnd Gnd CMOSN w=20 l=2
+  ad=120 pd=52 as=0 ps=0
M1123 a_759_1645# a_720_432# vdd w_753_1700# CMOSP w=20 l=2
+  ad=320 pd=152 as=0 ps=0
M1124 gnd a_3451_1603# a_3445_1607# Gnd CMOSN w=10 l=2
+  ad=0 pd=0 as=60 ps=32
M1125 out in vdd w_7_1393# CMOSP w=20 l=2
+  ad=140 pd=54 as=0 ps=0
M1126 s4 c4 a_3363_2433# Gnd CMOSN w=10 l=2
+  ad=0 pd=0 as=60 ps=32
M1127 a_179_1919# a_64_1943# vdd w_163_1945# CMOSP w=20 l=2
+  ad=140 pd=54 as=0 ps=0
M1128 a_n708_1523# a_n776_1523# vdd w_n721_1515# CMOSP w=20 l=2
+  ad=100 pd=50 as=0 ps=0
M1129 vdd a_50_1275# a_932_1072# w_926_1117# CMOSP w=20 l=2
+  ad=0 pd=0 as=220 ps=102
M1130 a_n727_879# clk a_n727_825# Gnd CMOSN w=20 l=2
+  ad=100 pd=50 as=0 ps=0
M1131 a_n863_823# clk a_n863_861# w_n876_853# CMOSP w=40 l=2
+  ad=200 pd=90 as=240 ps=92
M1132 a_751_2471# p1 vdd w_745_2535# CMOSP w=20 l=2
+  ad=340 pd=154 as=0 ps=0
M1133 a_774_2471# p2 a_766_2471# Gnd CMOSN w=50 l=2
+  ad=300 pd=112 as=300 ps=112
M1134 a_n775_1243# clk gnd Gnd CMOSN w=20 l=2
+  ad=120 pd=52 as=0 ps=0
M1135 a_165_1251# a_50_1275# gnd Gnd CMOSN w=10 l=2
+  ad=70 pd=34 as=0 ps=0
M1136 vdd a_n645_2579# a_83_2572# w_70_2566# CMOSP w=20 l=2
+  ad=0 pd=0 as=120 ps=52
M1137 a_n751_296# a_n819_296# vdd w_n764_288# CMOSP w=20 l=2
+  ad=100 pd=50 as=0 ps=0
M1138 a_726_356# a_720_432# gnd Gnd CMOSN w=20 l=2
+  ad=120 pd=52 as=0 ps=0
M1139 a_n707_1297# a_n775_1297# vdd w_n720_1289# CMOSP w=20 l=2
+  ad=100 pd=50 as=0 ps=0
M1140 a_47_635# a_n661_842# vdd w_34_629# CMOSP w=20 l=2
+  ad=120 pd=52 as=0 ps=0
M1141 a_n852_2837# b4 vdd w_n865_2829# CMOSP w=40 l=2
+  ad=240 pd=92 as=0 ps=0
M1142 vdd p2 a_749_2650# w_743_2705# CMOSP w=20 l=2
+  ad=0 pd=0 as=320 ps=152
M1143 a_n776_1985# a_n844_1929# a_n776_1931# Gnd CMOSN w=20 l=2
+  ad=100 pd=50 as=120 ps=52
M1144 a_759_1645# p2 vdd w_753_1700# CMOSP w=20 l=2
+  ad=0 pd=0 as=0 ps=0
M1145 a_n844_1467# b2 gnd Gnd CMOSN w=10 l=2
+  ad=50 pd=30 as=0 ps=0
M1146 c5 a_83_2572# vdd w_1023_2786# CMOSP w=20 l=2
+  ad=0 pd=0 as=0 ps=0
M1147 a_83_2572# a_n645_2579# a_83_2528# Gnd CMOSN w=20 l=2
+  ad=100 pd=50 as=120 ps=52
M1148 a_3358_n373# p0 vdd w_3345_n381# CMOSP w=20 l=2
+  ad=0 pd=0 as=0 ps=0
M1149 a_751_2471# p2 vdd w_745_2535# CMOSP w=20 l=2
+  ad=0 pd=0 as=0 ps=0
M1150 a_n887_240# b0 gnd Gnd CMOSN w=10 l=2
+  ad=50 pd=30 as=0 ps=0
M1151 a_726_400# a_720_432# vdd w_713_394# CMOSP w=20 l=2
+  ad=120 pd=52 as=0 ps=0
M1152 a_1036_2722# a_83_2572# c5 Gnd CMOSN w=50 l=2
+  ad=300 pd=112 as=250 ps=110
M1153 s4 a_3409_2500# a_3363_2465# w_3402_2457# CMOSP w=20 l=2
+  ad=120 pd=52 as=320 ps=152
M1154 a_n819_296# a_n887_240# a_n819_242# Gnd CMOSN w=20 l=2
+  ad=100 pd=50 as=120 ps=52
M1155 gnd a_162_611# a_772_2650# Gnd CMOSN w=40 l=2
+  ad=0 pd=0 as=240 ps=92
M1156 a_n711_2616# clk a_n711_2562# Gnd CMOSN w=20 l=2
+  ad=100 pd=50 as=120 ps=52
M1157 a_n704_2159# a_n772_2213# gnd Gnd CMOSN w=20 l=2
+  ad=120 pd=52 as=0 ps=0
M1158 a_n882_5# a0 gnd Gnd CMOSN w=10 l=2
+  ad=50 pd=30 as=0 ps=0
M1159 vdd a_n673_636# a_79_807# w_66_799# CMOSP w=20 l=2
+  ad=0 pd=0 as=0 ps=0
M1160 c4 a_759_1645# vdd w_1072_1940# CMOSP w=20 l=2
+  ad=0 pd=0 as=0 ps=0
M1161 a_50_1231# a_n642_1486# gnd Gnd CMOSN w=20 l=2
+  ad=120 pd=52 as=0 ps=0
M1162 a_n645_2579# a_n711_2616# vdd w_n661_2605# CMOSP w=20 l=2
+  ad=140 pd=54 as=0 ps=0
M1163 a_36_2118# a_n638_2176# vdd w_20_2144# CMOSP w=20 l=2
+  ad=140 pd=54 as=0 ps=0
M1164 a_761_2148# a_165_1251# a_761_2104# Gnd CMOSN w=20 l=2
+  ad=100 pd=50 as=0 ps=0
M1165 a_179_1919# a_64_1943# gnd Gnd CMOSN w=10 l=2
+  ad=70 pd=34 as=0 ps=0
M1166 a_766_1645# p3 a_759_1645# Gnd CMOSN w=40 l=2
+  ad=240 pd=92 as=200 ps=90
M1167 gnd a_720_432# a_777_1127# Gnd CMOSN w=30 l=2
+  ad=0 pd=0 as=0 ps=0
M1168 a_162_611# a_47_635# vdd w_146_637# CMOSP w=20 l=2
+  ad=140 pd=54 as=0 ps=0
M1169 a_764_2650# p3 a_756_2650# Gnd CMOSN w=40 l=2
+  ad=240 pd=92 as=0 ps=0
M1170 a_1101_1885# a_761_1890# a_1093_1885# Gnd CMOSN w=40 l=2
+  ad=0 pd=0 as=240 ps=92
M1171 a_n707_1243# a_n775_1297# gnd Gnd CMOSN w=20 l=2
+  ad=120 pd=52 as=0 ps=0
M1172 a_n751_242# a_n819_296# gnd Gnd CMOSN w=20 l=2
+  ad=0 pd=0 as=0 ps=0
M1173 a_n847_2560# clk a_n847_2598# w_n860_2590# CMOSP w=40 l=2
+  ad=200 pd=90 as=0 ps=0
M1174 a_3393_1607# p3 gnd Gnd CMOSN w=10 l=2
+  ad=0 pd=0 as=0 ps=0
M1175 p2 a_22_1450# a_82_1447# w_121_1439# CMOSP w=20 l=2
+  ad=120 pd=52 as=0 ps=0
M1176 a_n645_2579# a_n711_2616# gnd Gnd CMOSN w=10 l=2
+  ad=70 pd=34 as=0 ps=0
M1177 gnd p3 a_776_1890# Gnd CMOSN w=30 l=2
+  ad=0 pd=0 as=0 ps=0
M1178 a_3393_1639# a_3451_1603# s3 w_3432_1631# CMOSP w=20 l=2
+  ad=0 pd=0 as=0 ps=0
M1179 vdd p1 a_762_1127# w_756_1172# CMOSP w=20 l=2
+  ad=0 pd=0 as=0 ps=0
M1180 a_n807_673# clk vdd w_n820_665# CMOSP w=20 l=2
+  ad=100 pd=50 as=0 ps=0
M1181 a_20_727# a_n673_636# gnd Gnd CMOSN w=10 l=2
+  ad=70 pd=34 as=0 ps=0
M1182 vdd c4 a_3363_2465# w_3350_2457# CMOSP w=20 l=2
+  ad=0 pd=0 as=0 ps=0
M1183 a_n844_1505# b2 vdd w_n857_1497# CMOSP w=40 l=2
+  ad=0 pd=0 as=0 ps=0
M1184 a_n814_7# clk gnd Gnd CMOSN w=20 l=2
+  ad=0 pd=0 as=0 ps=0
M1185 a_96_2083# a_n638_2176# gnd Gnd CMOSN w=10 l=2
+  ad=60 pd=32 as=0 ps=0
M1186 a_1085_1885# a_64_1943# c4 Gnd CMOSN w=40 l=2
+  ad=240 pd=92 as=200 ps=90
M1187 a_165_1251# a_50_1275# vdd w_149_1277# CMOSP w=20 l=2
+  ad=140 pd=54 as=0 ps=0
M1188 a_79_807# a_20_727# p1 w_118_799# CMOSP w=20 l=2
+  ad=0 pd=0 as=0 ps=0
M1189 a_115_2712# a_n650_2818# gnd Gnd CMOSN w=10 l=2
+  ad=60 pd=32 as=0 ps=0
M1190 a_n843_1279# a2 vdd w_n856_1271# CMOSP w=40 l=2
+  ad=0 pd=0 as=0 ps=0
M1191 gnd a_3416_39# a_3410_43# Gnd CMOSN w=10 l=2
+  ad=0 pd=0 as=0 ps=0
M1192 a_n795_879# a_n863_823# a_n795_825# Gnd CMOSN w=20 l=2
+  ad=100 pd=50 as=120 ps=52
M1193 a_n863_823# b1 gnd Gnd CMOSN w=10 l=2
+  ad=50 pd=30 as=0 ps=0
M1194 a_759_2825# p4 a_752_2825# Gnd CMOSN w=30 l=2
+  ad=180 pd=72 as=150 ps=70
M1195 vdd p3 a_761_1890# w_755_1935# CMOSP w=20 l=2
+  ad=0 pd=0 as=0 ps=0
M1196 a_55_2747# a_n650_2818# gnd Gnd CMOSN w=10 l=2
+  ad=70 pd=34 as=0 ps=0
M1197 a_n844_1929# clk a_n844_1967# w_n857_1959# CMOSP w=40 l=2
+  ad=200 pd=90 as=240 ps=92
M1198 a_n776_1469# clk gnd Gnd CMOSN w=20 l=2
+  ad=0 pd=0 as=0 ps=0
M1199 a_n673_636# a_n739_673# gnd Gnd CMOSN w=10 l=2
+  ad=70 pd=34 as=0 ps=0
M1200 a_n819_296# clk vdd w_n832_288# CMOSP w=20 l=2
+  ad=100 pd=50 as=0 ps=0
M1201 a_36_2118# a_n638_2176# gnd Gnd CMOSN w=10 l=2
+  ad=70 pd=34 as=0 ps=0
M1202 a_n863_861# b1 vdd w_n876_853# CMOSP w=40 l=2
+  ad=0 pd=0 as=0 ps=0
M1203 a_56_2664# a_n645_2579# gnd Gnd CMOSN w=10 l=2
+  ad=70 pd=34 as=0 ps=0
M1204 a_64_1943# a_n642_1948# a_64_1899# Gnd CMOSN w=20 l=2
+  ad=100 pd=50 as=0 ps=0
M1205 s0 gnd a_3358_n405# Gnd CMOSN w=10 l=2
+  ad=100 pd=60 as=0 ps=0
M1206 a_726_400# p1 a_726_356# Gnd CMOSN w=20 l=2
+  ad=100 pd=50 as=0 ps=0
M1207 a_n739_673# a_n807_673# vdd w_n752_665# CMOSP w=20 l=2
+  ad=100 pd=50 as=0 ps=0
M1208 a_37_2035# a_n642_1948# gnd Gnd CMOSN w=10 l=2
+  ad=70 pd=34 as=0 ps=0
M1209 vdd a_n673_636# a_47_635# w_34_629# CMOSP w=20 l=2
+  ad=0 pd=0 as=0 ps=0
M1210 vdd a_n642_1948# a_64_1943# w_51_1937# CMOSP w=20 l=2
+  ad=0 pd=0 as=0 ps=0
M1211 a_3393_1639# p3 vdd w_3380_1631# CMOSP w=20 l=2
+  ad=0 pd=0 as=0 ps=0
M1212 vdd p1 a_726_400# w_713_394# CMOSP w=20 l=2
+  ad=0 pd=0 as=0 ps=0
M1213 a_752_2825# p3 vdd w_746_2870# CMOSP w=20 l=2
+  ad=0 pd=0 as=0 ps=0
M1214 gnd a_3421_2429# a_3415_2433# Gnd CMOSN w=10 l=2
+  ad=0 pd=0 as=0 ps=0
M1215 a_n819_242# clk gnd Gnd CMOSN w=20 l=2
+  ad=0 pd=0 as=0 ps=0
M1216 a_20_727# a_n673_636# vdd w_4_753# CMOSP w=20 l=2
+  ad=140 pd=54 as=0 ps=0
M1217 vdd a_179_1919# a_759_3032# w_746_3026# CMOSP w=20 l=2
+  ad=0 pd=0 as=0 ps=0
M1218 a_n779_2616# clk vdd w_n792_2608# CMOSP w=20 l=2
+  ad=100 pd=50 as=0 ps=0
M1219 a_n708_1469# a_n776_1523# gnd Gnd CMOSN w=20 l=2
+  ad=120 pd=52 as=0 ps=0
M1220 a_n795_879# clk vdd w_n808_871# CMOSP w=20 l=2
+  ad=100 pd=50 as=0 ps=0
M1221 a_115_2744# a_n650_2818# vdd w_102_2736# CMOSP w=20 l=2
+  ad=0 pd=0 as=0 ps=0
M1222 a_n776_1985# clk vdd w_n789_1977# CMOSP w=20 l=2
+  ad=100 pd=50 as=0 ps=0
M1223 a_50_1275# a_n642_1486# vdd w_37_1269# CMOSP w=20 l=2
+  ad=120 pd=52 as=0 ps=0
M1224 a_824_356# a_726_400# gnd Gnd CMOSN w=20 l=2
+  ad=120 pd=52 as=0 ps=0
M1225 a_758_2471# p4 a_751_2471# Gnd CMOSN w=50 l=2
+  ad=300 pd=112 as=250 ps=110
M1226 a_3358_75# a_3416_39# s1 w_3397_67# CMOSP w=20 l=2
+  ad=0 pd=0 as=0 ps=0
M1227 a_148_2083# a_36_2118# p3 Gnd CMOSN w=10 l=2
+  ad=60 pd=32 as=51 ps=31
M1228 a_824_400# a_726_400# vdd w_811_394# CMOSP w=20 l=2
+  ad=120 pd=52 as=0 ps=0
M1229 a_55_2747# a_n650_2818# vdd w_39_2773# CMOSP w=20 l=2
+  ad=140 pd=54 as=0 ps=0
M1230 vdd p4 a_749_2650# w_743_2705# CMOSP w=20 l=2
+  ad=0 pd=0 as=0 ps=0
M1231 a_n779_2562# clk gnd Gnd CMOSN w=20 l=2
+  ad=0 pd=0 as=0 ps=0
M1232 vdd a_165_1251# a_761_2148# w_748_2142# CMOSP w=20 l=2
+  ad=0 pd=0 as=0 ps=0
M1233 a_947_1072# a_775_1022# a_939_1072# Gnd CMOSN w=30 l=2
+  ad=180 pd=72 as=0 ps=0
M1234 a_n673_636# a_n739_673# vdd w_n689_662# CMOSP w=20 l=2
+  ad=140 pd=54 as=0 ps=0
M1235 gnd out a_134_1415# Gnd CMOSN w=10 l=2
+  ad=0 pd=0 as=0 ps=0
M1236 in a_n707_1297# gnd Gnd CMOSN w=10 l=2
+  ad=70 pd=34 as=0 ps=0
M1237 a_n650_2818# a_n716_2855# vdd w_n666_2844# CMOSP w=20 l=2
+  ad=140 pd=54 as=0 ps=0
M1238 a_167_2712# a_55_2747# p4 Gnd CMOSN w=10 l=2
+  ad=60 pd=32 as=51 ps=31
M1239 a_751_2471# p4 vdd w_745_2535# CMOSP w=20 l=2
+  ad=0 pd=0 as=0 ps=0
M1240 a_96_2115# a_n638_2176# vdd w_83_2107# CMOSP w=20 l=2
+  ad=0 pd=0 as=0 ps=0
M1241 a_775_978# p2 gnd Gnd CMOSN w=20 l=2
+  ad=120 pd=52 as=0 ps=0
M1242 a_n887_278# b0 vdd w_n900_270# CMOSP w=40 l=2
+  ad=240 pd=92 as=0 ps=0
M1243 a_3414_421# a_3408_488# s2 Gnd CMOSN w=10 l=2
+  ad=60 pd=32 as=100 ps=60
M1244 a_n739_673# clk a_n739_619# Gnd CMOSN w=20 l=2
+  ad=100 pd=50 as=120 ps=52
M1245 a_n875_617# clk a_n875_655# w_n888_647# CMOSP w=40 l=2
+  ad=200 pd=90 as=240 ps=92
M1246 vdd a_752_2825# c5 w_1023_2786# CMOSP w=20 l=2
+  ad=0 pd=0 as=0 ps=0
M1247 a_56_2664# a_n645_2579# vdd w_40_2690# CMOSP w=20 l=2
+  ad=140 pd=54 as=0 ps=0
M1248 a_932_1072# a_775_1022# vdd w_926_1117# CMOSP w=20 l=2
+  ad=0 pd=0 as=0 ps=0
M1249 a_759_2988# p4 gnd Gnd CMOSN w=20 l=2
+  ad=0 pd=0 as=0 ps=0
M1250 a_1060_2722# a_752_2825# a_1052_2722# Gnd CMOSN w=50 l=2
+  ad=0 pd=0 as=0 ps=0
M1251 a_782_2471# a_720_432# a_774_2471# Gnd CMOSN w=50 l=2
+  ad=0 pd=0 as=0 ps=0
M1252 a_37_2035# a_n642_1948# vdd w_21_2061# CMOSP w=20 l=2
+  ad=140 pd=54 as=0 ps=0
M1253 c4 a_761_2148# vdd w_1072_1940# CMOSP w=20 l=2
+  ad=0 pd=0 as=0 ps=0
M1254 a_n795_825# clk gnd Gnd CMOSN w=20 l=2
+  ad=0 pd=0 as=0 ps=0
M1255 a_n711_2616# a_n779_2616# vdd w_n724_2608# CMOSP w=20 l=2
+  ad=100 pd=50 as=0 ps=0
M1256 a_n704_2213# clk a_n704_2159# Gnd CMOSN w=20 l=2
+  ad=100 pd=50 as=0 ps=0
M1257 a_n776_1931# clk gnd Gnd CMOSN w=20 l=2
+  ad=0 pd=0 as=0 ps=0
M1258 vdd p1 a_759_1645# w_753_1700# CMOSP w=20 l=2
+  ad=0 pd=0 as=0 ps=0
M1259 a_n882_5# clk a_n882_43# w_n895_35# CMOSP w=40 l=2
+  ad=200 pd=90 as=0 ps=0
M1260 vdd a_751_2471# c5 w_1023_2786# CMOSP w=20 l=2
+  ad=0 pd=0 as=0 ps=0
M1261 a_3363_2433# p4 gnd Gnd CMOSN w=10 l=2
+  ad=0 pd=0 as=0 ps=0
M1262 a_769_1127# p1 a_762_1127# Gnd CMOSN w=30 l=2
+  ad=0 pd=0 as=150 ps=70
M1263 a_3410_n405# a_3404_n338# s0 Gnd CMOSN w=10 l=2
+  ad=0 pd=0 as=0 ps=0
M1264 vdd gnd a_3358_n373# w_3345_n381# CMOSP w=20 l=2
+  ad=0 pd=0 as=0 ps=0
M1265 a_n887_240# clk a_n887_278# w_n900_270# CMOSP w=40 l=2
+  ad=200 pd=90 as=0 ps=0
M1266 vdd a_720_432# a_751_2471# w_745_2535# CMOSP w=20 l=2
+  ad=0 pd=0 as=0 ps=0
M1267 a_n708_1985# a_n776_1985# vdd w_n721_1977# CMOSP w=20 l=2
+  ad=100 pd=50 as=0 ps=0
M1268 a_1044_2722# a_751_2471# a_1036_2722# Gnd CMOSN w=50 l=2
+  ad=0 pd=0 as=0 ps=0
M1269 a_83_2572# a_n650_2818# vdd w_70_2566# CMOSP w=20 l=2
+  ad=0 pd=0 as=0 ps=0
M1270 a_3363_2465# a_3421_2429# s4 w_3402_2457# CMOSP w=20 l=2
+  ad=0 pd=0 as=0 ps=0
M1271 a_n847_2560# a4 gnd Gnd CMOSN w=10 l=2
+  ad=50 pd=30 as=0 ps=0
M1272 a_n711_2562# a_n779_2616# gnd Gnd CMOSN w=20 l=2
+  ad=0 pd=0 as=0 ps=0
M1273 a_768_1890# a_162_611# a_761_1890# Gnd CMOSN w=30 l=2
+  ad=0 pd=0 as=150 ps=70
M1274 gnd a_720_432# a_782_1645# Gnd CMOSN w=40 l=2
+  ad=0 pd=0 as=0 ps=0
M1275 p2 in a_82_1415# Gnd CMOSN w=10 l=2
+  ad=0 pd=0 as=0 ps=0
M1276 a_83_2528# a_n650_2818# gnd Gnd CMOSN w=20 l=2
+  ad=0 pd=0 as=0 ps=0
M1277 a_50_1275# in a_50_1231# Gnd CMOSN w=20 l=2
+  ad=100 pd=50 as=0 ps=0
M1278 a_3358_43# p1 gnd Gnd CMOSN w=10 l=2
+  ad=0 pd=0 as=0 ps=0
M1279 a_n650_2818# a_n716_2855# gnd Gnd CMOSN w=10 l=2
+  ad=70 pd=34 as=0 ps=0
M1280 a_772_2650# p2 a_764_2650# Gnd CMOSN w=40 l=2
+  ad=0 pd=0 as=0 ps=0
M1281 vdd a_162_611# a_761_1890# w_755_1935# CMOSP w=20 l=2
+  ad=0 pd=0 as=0 ps=0
M1282 a_774_1645# p2 a_766_1645# Gnd CMOSN w=40 l=2
+  ad=0 pd=0 as=0 ps=0
M1283 a_n807_619# clk gnd Gnd CMOSN w=20 l=2
+  ad=120 pd=52 as=0 ps=0
M1284 a_82_1447# out p2 w_121_1439# CMOSP w=20 l=2
+  ad=0 pd=0 as=0 ps=0
M1285 in a_n707_1297# vdd w_n657_1286# CMOSP w=20 l=2
+  ad=140 pd=54 as=0 ps=0
M1286 p4 a_55_2747# a_115_2744# w_154_2736# CMOSP w=20 l=2
+  ad=0 pd=0 as=0 ps=0
M1287 p3 a_n642_1948# a_96_2083# Gnd CMOSN w=10 l=2
+  ad=0 pd=0 as=0 ps=0
M1288 a_n844_1929# a3 gnd Gnd CMOSN w=10 l=2
+  ad=50 pd=30 as=0 ps=0
M1289 a_n708_1931# a_n776_1985# gnd Gnd CMOSN w=20 l=2
+  ad=0 pd=0 as=0 ps=0
M1290 s2 a_3408_488# a_3362_453# w_3401_445# CMOSP w=20 l=2
+  ad=120 pd=52 as=0 ps=0
M1291 a_762_1127# p2 vdd w_756_1172# CMOSP w=20 l=2
+  ad=0 pd=0 as=0 ps=0
M1292 a_n875_617# a1 gnd Gnd CMOSN w=10 l=2
+  ad=50 pd=30 as=0 ps=0
M1293 p3 a_36_2118# a_96_2115# w_135_2107# CMOSP w=20 l=2
+  ad=0 pd=0 as=0 ps=0
M1294 a_n642_1486# a_n708_1523# gnd Gnd CMOSN w=10 l=2
+  ad=70 pd=34 as=0 ps=0
M1295 a_824_400# a_47_635# a_824_356# Gnd CMOSN w=20 l=2
+  ad=100 pd=50 as=0 ps=0
M1296 p4 a_n645_2579# a_115_2712# Gnd CMOSN w=10 l=2
+  ad=0 pd=0 as=0 ps=0
M1297 a_1093_1885# a_759_1645# a_1085_1885# Gnd CMOSN w=40 l=2
+  ad=0 pd=0 as=0 ps=0
M1298 a_n707_1297# clk a_n707_1243# Gnd CMOSN w=20 l=2
+  ad=100 pd=50 as=0 ps=0
M1299 a_n807_673# a_n875_617# a_n807_619# Gnd CMOSN w=20 l=2
+  ad=100 pd=50 as=0 ps=0
M1300 a_198_2548# a_83_2572# vdd w_182_2574# CMOSP w=20 l=2
+  ad=140 pd=54 as=0 ps=0
M1301 a_n784_2855# a_n852_2799# a_n784_2801# Gnd CMOSN w=20 l=2
+  ad=100 pd=50 as=0 ps=0
M1302 a_n840_2157# clk a_n840_2195# w_n853_2187# CMOSP w=40 l=2
+  ad=200 pd=90 as=0 ps=0
M1303 vdd a_47_635# a_824_400# w_811_394# CMOSP w=20 l=2
+  ad=0 pd=0 as=0 ps=0
M1304 a_767_2825# p3 a_759_2825# Gnd CMOSN w=30 l=2
+  ad=0 pd=0 as=0 ps=0
M1305 a_3363_2465# p4 vdd w_3350_2457# CMOSP w=20 l=2
+  ad=0 pd=0 as=0 ps=0
M1306 a_n844_1967# a3 vdd w_n857_1959# CMOSP w=40 l=2
+  ad=0 pd=0 as=0 ps=0
M1307 a_n638_2176# a_n704_2213# gnd Gnd CMOSN w=10 l=2
+  ad=70 pd=34 as=0 ps=0
M1308 a_775_1022# a_162_611# a_775_978# Gnd CMOSN w=20 l=2
+  ad=100 pd=50 as=0 ps=0
M1309 gnd a_3420_417# a_3414_421# Gnd CMOSN w=10 l=2
+  ad=0 pd=0 as=0 ps=0
M1310 s2 a_824_400# a_3362_421# Gnd CMOSN w=10 l=2
+  ad=0 pd=0 as=60 ps=32
M1311 a_n739_619# a_n807_673# gnd Gnd CMOSN w=20 l=2
+  ad=0 pd=0 as=0 ps=0
M1312 a_n875_655# a1 vdd w_n888_647# CMOSP w=40 l=2
+  ad=0 pd=0 as=0 ps=0
M1313 vdd in a_82_1447# w_69_1439# CMOSP w=20 l=2
+  ad=0 pd=0 as=0 ps=0
M1314 s0 a_3404_n338# a_3358_n373# w_3397_n381# CMOSP w=20 l=2
+  ad=0 pd=0 as=0 ps=0
M1315 a_22_1450# a_n642_1486# gnd Gnd CMOSN w=10 l=2
+  ad=70 pd=34 as=0 ps=0
M1316 a_3358_75# p1 vdd w_3345_67# CMOSP w=20 l=2
+  ad=0 pd=0 as=0 ps=0
M1317 a_775_1022# p2 vdd w_762_1016# CMOSP w=20 l=2
+  ad=0 pd=0 as=0 ps=0
M1318 a_3362_421# p2 gnd Gnd CMOSN w=10 l=2
+  ad=0 pd=0 as=0 ps=0
M1319 a_n746_61# clk a_n746_7# Gnd CMOSN w=20 l=2
+  ad=100 pd=50 as=0 ps=0
M1320 a_198_2548# a_83_2572# gnd Gnd CMOSN w=10 l=2
+  ad=70 pd=34 as=0 ps=0
M1321 a_n772_2213# a_n840_2157# a_n772_2159# Gnd CMOSN w=20 l=2
+  ad=100 pd=50 as=0 ps=0
M1322 a_n716_2855# clk a_n716_2801# Gnd CMOSN w=20 l=2
+  ad=100 pd=50 as=0 ps=0
M1323 vdd a_165_1251# a_752_2825# w_746_2870# CMOSP w=20 l=2
+  ad=0 pd=0 as=0 ps=0
M1324 a_749_2650# a_162_611# vdd w_743_2705# CMOSP w=20 l=2
+  ad=0 pd=0 as=0 ps=0
M1325 a_3445_1607# a_3439_1674# s3 Gnd CMOSN w=10 l=2
+  ad=0 pd=0 as=0 ps=0
M1326 vdd a_n645_2579# a_115_2744# w_102_2736# CMOSP w=20 l=2
+  ad=0 pd=0 as=0 ps=0
M1327 vdd in a_50_1275# w_37_1269# CMOSP w=20 l=2
+  ad=0 pd=0 as=0 ps=0
M1328 a_766_2471# p3 a_758_2471# Gnd CMOSN w=50 l=2
+  ad=0 pd=0 as=0 ps=0
M1329 a_n775_1297# a_n843_1241# a_n775_1243# Gnd CMOSN w=20 l=2
+  ad=100 pd=50 as=0 ps=0
M1330 vdd a_n642_1948# a_96_2115# w_83_2107# CMOSP w=20 l=2
+  ad=0 pd=0 as=0 ps=0
M1331 gnd a_37_2035# a_148_2083# Gnd CMOSN w=10 l=2
+  ad=0 pd=0 as=0 ps=0
M1332 a_79_775# a_n661_842# gnd Gnd CMOSN w=10 l=2
+  ad=0 pd=0 as=0 ps=0
M1333 a_n852_2799# clk a_n852_2837# w_n865_2829# CMOSP w=40 l=2
+  ad=200 pd=90 as=0 ps=0
M1334 a_749_2650# p3 vdd w_743_2705# CMOSP w=20 l=2
+  ad=0 pd=0 as=0 ps=0
M1335 vdd p3 a_759_1645# w_753_1700# CMOSP w=20 l=2
+  ad=0 pd=0 as=0 ps=0
M1336 gnd a_762_1127# a_947_1072# Gnd CMOSN w=30 l=2
+  ad=0 pd=0 as=0 ps=0
M1337 vdd a_761_1890# c4 w_1072_1940# CMOSP w=20 l=2
+  ad=0 pd=0 as=0 ps=0
M1338 a_n708_1523# clk a_n708_1469# Gnd CMOSN w=20 l=2
+  ad=100 pd=50 as=0 ps=0
M1339 vdd p3 a_751_2471# w_745_2535# CMOSP w=20 l=2
+  ad=0 pd=0 as=0 ps=0
M1340 a_n772_2213# clk vdd w_n785_2205# CMOSP w=20 l=2
+  ad=100 pd=50 as=0 ps=0
M1341 a_n642_1486# a_n708_1523# vdd w_n658_1512# CMOSP w=20 l=2
+  ad=140 pd=54 as=0 ps=0
M1342 gnd a_56_2664# a_167_2712# Gnd CMOSN w=10 l=2
+  ad=0 pd=0 as=0 ps=0
M1343 a_3362_453# a_3420_417# s2 w_3401_445# CMOSP w=20 l=2
+  ad=0 pd=0 as=0 ps=0
M1344 vdd a_824_400# a_3362_453# w_3349_445# CMOSP w=20 l=2
+  ad=0 pd=0 as=0 ps=0
M1345 c5 a_759_3032# vdd w_1023_2786# CMOSP w=20 l=2
+  ad=0 pd=0 as=0 ps=0
M1346 a_22_1450# a_n642_1486# vdd w_6_1476# CMOSP w=20 l=2
+  ad=140 pd=54 as=0 ps=0
M1347 vdd a_762_1127# a_932_1072# w_926_1117# CMOSP w=20 l=2
+  ad=0 pd=0 as=0 ps=0
C0 w_7_1393# out 0.05fF
C1 w_121_1439# a_82_1447# 0.14fF
C2 w_n888_647# vdd 0.08fF
C3 a_36_2118# a_96_2115# 0.51fF
C4 a_3409_2500# a_3363_2465# 0.51fF
C5 a_n727_879# gnd 0.05fF
C6 a_726_400# a_726_356# 0.21fF
C7 a_n746_61# gnd 0.05fF
C8 2XOR_0/b 2XOR_0/w_66_6# 0.10fF
C9 p4 w_746_2870# 0.12fF
C10 a_824_400# p1 0.01fF
C11 c4 a_720_432# 0.09fF
C12 a_n650_2818# a_n645_2579# 0.56fF
C13 clk a_n843_1241# 0.12fF
C14 a_n779_2616# vdd 0.45fF
C15 w_83_2107# a_36_2118# 0.07fF
C16 2XOR_0/b 2XOR_0/a_79_14# 0.08fF
C17 w_n895_35# vdd 0.08fF
C18 p3 a_761_1890# 0.08fF
C19 a_3420_417# a_3408_488# 0.17fF
C20 a_n739_673# gnd 0.05fF
C21 a_774_2471# a_782_2471# 0.52fF
C22 w_3380_1631# a_3393_1639# 0.05fF
C23 w_51_1937# a_64_1943# 0.02fF
C24 w_748_2142# vdd 0.14fF
C25 inverter1_10/w_n19_78# a_3404_n338# 0.05fF
C26 w_756_1172# a_762_1127# 0.12fF
C27 p4 w_743_2705# 0.14fF
C28 a_824_356# gnd 0.21fF
C29 p1 a_19_810# 0.08fF
C30 a_55_2747# vdd 0.21fF
C31 p2 a_162_611# 1.00fF
C32 out gnd 0.18fF
C33 p2 a_165_1251# 0.21fF
C34 a_3416_n409# gnd 0.22fF
C35 a_3420_417# w_3401_445# 0.10fF
C36 a_824_400# w_811_394# 0.02fF
C37 a_761_1890# gnd 0.23fF
C38 a_n819_242# gnd 0.21fF
C39 w_n857_1959# a_n844_1967# 0.01fF
C40 w_n808_871# a_n795_879# 0.05fF
C41 w_762_1016# a_162_611# 0.09fF
C42 2XOR_0/a_131_n18# gnd 0.10fF
C43 w_154_2736# a_56_2664# 0.10fF
C44 w_102_2736# a_115_2744# 0.05fF
C45 a_50_1275# a_762_1127# 0.10fF
C46 p2 w_121_1439# 0.03fF
C47 p2 w_745_2535# 0.12fF
C48 a_756_2650# a_764_2650# 0.41fF
C49 w_n857_1497# clk 0.10fF
C50 a_n776_1985# vdd 0.45fF
C51 a_n746_7# gnd 0.21fF
C52 c4 a_1085_1885# 0.47fF
C53 w_n860_2590# clk 0.10fF
C54 a_759_2825# a_767_2825# 0.31fF
C55 w_146_637# a_162_611# 0.05fF
C56 a_162_611# vdd 0.74fF
C57 a_n661_842# vdd 0.95fF
C58 p2 a_720_432# 1.18fF
C59 a_n843_1241# gnd 0.38fF
C60 a_165_1251# vdd 0.44fF
C61 2XOR_0/a_125_49# 2XOR_0/w_66_6# 0.07fF
C62 2XOR_0/a a_n751_296# 0.04fF
C63 a_83_2572# c5 0.15fF
C64 inverter1_5/w_n19_78# a_824_400# 0.06fF
C65 a_3439_1674# w_3432_1631# 0.10fF
C66 a_932_1072# p3 0.28fF
C67 inverter1_2/w_n19_78# a_3409_2500# 0.05fF
C68 w_n832_288# clk 0.10fF
C69 p2 a_82_1447# 0.72fF
C70 a_3416_n409# s0 0.13fF
C71 2XOR_0/a_125_49# 2XOR_0/a_79_14# 0.51fF
C72 gnd a_3358_n373# 0.08fF
C73 w_146_637# a_47_635# 0.06fF
C74 a_47_635# vdd 0.72fF
C75 w_745_2535# vdd 0.16fF
C76 a_3421_2429# s4 0.13fF
C77 w_n720_1289# a_n775_1297# 0.10fF
C78 a_776_1890# gnd 0.31fF
C79 a_n642_1948# a_64_1943# 0.08fF
C80 a_3362_453# vdd 0.49fF
C81 a_n708_1523# a_n708_1469# 0.21fF
C82 s3 vdd 0.09fF
C83 2XOR_0/a_137_n22# vdd 0.21fF
C84 vdd a_720_432# 0.91fF
C85 gnd 2NAND1_0/a_3_n40# 0.21fF
C86 p4 a_179_1919# 0.32fF
C87 a_751_2471# a_162_611# 0.05fF
C88 a_55_2747# a_115_2744# 0.51fF
C89 w_n661_2605# a_n645_2579# 0.05fF
C90 inverter1_4/w_n19_78# vdd 0.12fF
C91 w_746_2870# a_752_2825# 0.12fF
C92 a_762_1127# a_775_1022# 0.29fF
C93 a_932_1072# gnd 0.11fF
C94 c4 vdd 1.17fF
C95 a_n784_2855# a_n784_2801# 0.21fF
C96 a_759_3032# c5 0.15fF
C97 a_82_1447# vdd 0.49fF
C98 p4 w_746_3026# 0.09fF
C99 w_n900_270# a_n887_240# 0.07fF
C100 a_3363_2433# gnd 0.10fF
C101 a_n844_1505# a_n844_1467# 0.41fF
C102 w_n654_2202# a_n638_2176# 0.05fF
C103 a_n784_2855# vdd 0.45fF
C104 clk a_n840_2157# 0.12fF
C105 w_n789_1977# clk 0.10fF
C106 a_3358_n373# s0 0.72fF
C107 w_745_2535# a_751_2471# 0.18fF
C108 a_3404_110# w_3397_67# 0.10fF
C109 a_3409_2500# w_3350_2457# 0.07fF
C110 2XOR_0/inverter1_0/w_n19_78# 2XOR_0/a_125_49# 0.05fF
C111 w_n827_53# a_n814_61# 0.05fF
C112 2NAND1_0/out 2NAND1_0/w_n10_n2# 0.02fF
C113 clk a_n863_823# 0.12fF
C114 a_751_2471# a_720_432# 0.25fF
C115 a_3420_417# a_3362_453# 0.12fF
C116 a_n775_1243# gnd 0.21fF
C117 p3 a_83_2572# 0.10fF
C118 w_3397_67# a_3358_75# 0.14fF
C119 a_761_2148# gnd 0.12fF
C120 w_n865_2829# clk 0.10fF
C121 a_932_1072# a_3451_1603# 0.04fF
C122 clk a_n875_617# 0.12fF
C123 p2 w_762_1016# 0.09fF
C124 w_102_2736# a_n650_2818# 0.10fF
C125 w_n785_2205# vdd 0.08fF
C126 a_3404_n338# w_3397_n381# 0.10fF
C127 w_n857_1497# a_n844_1467# 0.07fF
C128 a_n775_1297# a_n775_1243# 0.21fF
C129 a_772_2650# gnd 0.41fF
C130 a_83_2572# gnd 0.28fF
C131 w_1023_2786# vdd 0.14fF
C132 p1 w_713_394# 0.09fF
C133 p2 vdd 1.49fF
C134 a_752_2825# a_767_2825# 0.05fF
C135 a_3409_2500# gnd 0.37fF
C136 a_162_611# a_759_1645# 0.11fF
C137 a_3393_1639# s3 0.72fF
C138 w_n788_1289# clk 0.10fF
C139 w_762_1016# vdd 0.14fF
C140 a_n840_2157# gnd 0.38fF
C141 clk a_n814_61# 0.03fF
C142 w_755_1935# a_162_611# 0.12fF
C143 a_36_2118# a_37_2035# 0.17fF
C144 a_n863_823# gnd 0.38fF
C145 s2 a_3414_421# 0.14fF
C146 a_n746_61# a_n746_7# 0.21fF
C147 a_56_2664# gnd 0.18fF
C148 w_n856_1271# a2 0.09fF
C149 a_759_3032# gnd 0.22fF
C150 2XOR_0/b 2XOR_0/a_137_n22# 0.04fF
C151 w_146_637# vdd 0.13fF
C152 a_n650_2818# a_55_2747# 0.12fF
C153 w_1023_2786# a_751_2471# 0.12fF
C154 a_n673_636# gnd 0.29fF
C155 p2 a_751_2471# 0.15fF
C156 a_759_1645# a_720_432# 0.25fF
C157 w_n764_288# vdd 0.08fF
C158 inverter1_7/w_n19_78# a_3416_39# 0.05fF
C159 a_1044_2722# a_1052_2722# 0.52fF
C160 a_824_400# a_3408_488# 0.00fF
C161 a_96_2115# vdd 0.49fF
C162 p3 a_64_1943# 0.09fF
C163 c4 a_759_1645# 0.15fF
C164 in a_82_1447# 0.08fF
C165 a_n875_617# gnd 0.38fF
C166 a_766_2471# a_774_2471# 0.52fF
C167 2XOR_0/w_118_6# 2XOR_0/a_79_14# 0.14fF
C168 a_3421_2429# w_3402_2457# 0.10fF
C169 a_3416_39# a_3404_110# 0.17fF
C170 w_3345_n381# vdd 0.12fF
C171 a_761_2148# a_761_2104# 0.21fF
C172 w_83_2107# vdd 0.12fF
C173 inverter1_10/w_n19_78# p0 0.07fF
C174 2XOR_0/a_79_14# p0 0.72fF
C175 a_3404_110# inverter1_8/w_n19_78# 0.05fF
C176 a_932_1072# a_939_1072# 0.36fF
C177 p4 w_154_2736# 0.03fF
C178 a_3416_39# a_3358_75# 0.12fF
C179 a_n882_43# a_n882_5# 0.41fF
C180 a_3414_421# gnd 0.10fF
C181 w_746_2870# a_165_1251# 0.12fF
C182 w_1072_1940# a_761_1890# 0.14fF
C183 clk a4 0.07fF
C184 a_n711_2616# vdd 0.27fF
C185 a_198_2548# gnd 0.07fF
C186 w_83_2107# a_96_2115# 0.05fF
C187 a_751_2471# vdd 1.39fF
C188 a_22_1450# gnd 0.37fF
C189 a_n642_1486# vdd 0.95fF
C190 a_3416_39# gnd 0.18fF
C191 a_64_1943# gnd 0.09fF
C192 a_3420_417# vdd 0.21fF
C193 a_n751_296# gnd 0.05fF
C194 a_782_2471# gnd 0.52fF
C195 p1 a_131_775# 0.14fF
C196 w_n876_853# a_n863_823# 0.07fF
C197 s1 a_3358_43# 0.10fF
C198 a_3439_1674# w_3380_1631# 0.07fF
C199 w_3_836# a_n661_842# 0.07fF
C200 a_3416_n409# a_3358_n373# 0.12fF
C201 w_743_2705# a_162_611# 0.14fF
C202 a_3410_43# gnd 0.10fF
C203 w_4_753# a_n673_636# 0.06fF
C204 w_66_799# a_79_807# 0.05fF
C205 a_3421_2429# a_3363_2465# 0.12fF
C206 w_118_799# a_20_727# 0.10fF
C207 a_115_2744# vdd 0.49fF
C208 a_n795_879# vdd 0.45fF
C209 inverter1_11/w_n19_78# vdd 0.10fF
C210 2XOR_0/a 2XOR_0/w_66_6# 0.10fF
C211 2XOR_0/a_125_49# 2XOR_0/a_137_n22# 0.17fF
C212 w_n788_1289# a_n775_1297# 0.05fF
C213 p3 p1 0.19fF
C214 a_761_1890# a_776_1890# 0.05fF
C215 a_749_2650# a_772_2650# 0.05fF
C216 a_n642_1948# a_n708_1985# 0.04fF
C217 w_n888_647# a_n875_655# 0.01fF
C218 a_20_727# vdd 0.21fF
C219 a_165_1251# a_50_1275# 0.05fF
C220 inverter1_2/w_n19_78# p4 0.07fF
C221 p1 a_3404_110# 0.12fF
C222 w_756_1172# a_720_432# 0.12fF
C223 p4 c5 0.10fF
C224 a_3393_1639# vdd 0.49fF
C225 p2 a_759_1645# 0.15fF
C226 w_6_1476# vdd 0.12fF
C227 a_n807_673# vdd 0.45fF
C228 w_70_2566# vdd 0.22fF
C229 clk a3 0.07fF
C230 a_64_1899# gnd 0.21fF
C231 p2 w_755_1935# 0.12fF
C232 w_n654_2202# a_n704_2213# 0.06fF
C233 p1 gnd 0.36fF
C234 gnd 2NAND1_0/out 0.09fF
C235 2XOR_0/b vdd 0.67fF
C236 w_n857_1959# clk 0.10fF
C237 w_713_394# a_726_400# 0.02fF
C238 a_n638_2176# a_36_2118# 0.12fF
C239 a_50_1275# a_720_432# 0.19fF
C240 p4 a_115_2712# 0.10fF
C241 in vdd 0.67fF
C242 inverter1_9/w_n19_78# vdd 0.11fF
C243 a_759_1645# vdd 1.10fF
C244 p1 w_753_1700# 0.14fF
C245 w_n900_270# b0 0.09fF
C246 w_3345_67# a_720_432# 0.10fF
C247 a_3404_n338# vdd 0.21fF
C248 w_6_1476# a_n642_1486# 0.07fF
C249 w_182_2574# a_83_2572# 0.06fF
C250 w_n701_285# a_n751_296# 0.06fF
C251 a_761_2148# a_761_1890# 1.59fF
C252 a_162_611# a_775_1022# 0.17fF
C253 w_755_1935# vdd 0.11fF
C254 a_824_400# a_47_635# 0.08fF
C255 p4 w_3350_2457# 0.10fF
C256 2XOR_0/inverter1_0/w_n19_78# 2XOR_0/a 0.07fF
C257 w_n895_35# a_n882_5# 0.07fF
C258 clk b1 0.07fF
C259 w_n853_2187# vdd 0.08fF
C260 a_824_400# a_3362_453# 0.08fF
C261 w_1072_1940# a_761_2148# 0.14fF
C262 a_3404_n338# w_3345_n381# 0.07fF
C263 a_824_400# a_720_432# 0.10fF
C264 a_1101_1885# gnd 0.41fF
C265 a_759_1645# a_774_1645# 0.05fF
C266 a_n661_842# a_19_810# 0.12fF
C267 w_n857_1497# a_n844_1505# 0.01fF
C268 p4 p3 1.20fF
C269 a_3451_1603# w_3432_1631# 0.10fF
C270 a_n642_1486# in 0.56fF
C271 clk b4 0.07fF
C272 a_n847_2598# a_n847_2560# 0.41fF
C273 a_n673_636# a_79_807# 0.08fF
C274 p2 w_756_1172# 0.12fF
C275 a_932_1072# w_926_1117# 0.12fF
C276 clk a1 0.07fF
C277 a_n716_2855# a_n716_2801# 0.21fF
C278 w_n856_1271# clk 0.10fF
C279 a_n673_636# a_n739_673# 0.04fF
C280 a_n847_2598# vdd 0.41fF
C281 p2 w_743_2705# 0.14fF
C282 w_746_2870# vdd 0.12fF
C283 2XOR_0/b inverter1_11/w_n19_78# 0.05fF
C284 a_n650_2818# vdd 0.95fF
C285 2XOR_0/a_125_49# vdd 0.21fF
C286 inverter1_3/w_n19_78# vdd 0.11fF
C287 a_36_2118# a_n642_1948# 0.00fF
C288 p4 gnd 0.16fF
C289 a_n645_2579# gnd 0.29fF
C290 a_47_635# a_47_591# 0.21fF
C291 p2 a_50_1275# 0.06fF
C292 clk a_n887_240# 0.12fF
C293 c5 a_1060_2722# 0.05fF
C294 w_756_1172# vdd 0.12fF
C295 a_752_2825# c5 0.15fF
C296 s4 vdd 0.09fF
C297 w_n658_1974# a_n708_1985# 0.06fF
C298 a_762_1127# gnd 0.05fF
C299 w_182_2574# a_198_2548# 0.05fF
C300 w_69_1439# a_22_1450# 0.07fF
C301 w_3_836# vdd 0.12fF
C302 w_743_2705# vdd 0.12fF
C303 w_n689_662# vdd 0.10fF
C304 a_n727_825# gnd 0.21fF
C305 a_50_1275# vdd 0.70fF
C306 a_167_2712# gnd 0.10fF
C307 2XOR_0/a_137_n22# 2XOR_0/w_118_6# 0.10fF
C308 w_n900_270# vdd 0.08fF
C309 a_3439_1674# s3 0.08fF
C310 a_37_2035# vdd 0.21fF
C311 a_824_400# p2 0.28fF
C312 inverter1_4/w_n19_78# a_3439_1674# 0.05fF
C313 a_n711_2562# gnd 0.21fF
C314 a_22_1450# out 0.17fF
C315 p0 a_720_432# 0.32fF
C316 a_n887_278# a_n887_240# 0.41fF
C317 2XOR_0/a_137_n22# p0 0.13fF
C318 a_758_2471# a_766_2471# 0.52fF
C319 a_n708_1523# vdd 0.27fF
C320 w_3345_67# vdd 0.12fF
C321 a_n708_1469# gnd 0.21fF
C322 a_64_1943# a_761_1890# 0.09fF
C323 a_n708_1985# gnd 0.05fF
C324 a_n844_1967# vdd 0.41fF
C325 a_37_2035# a_96_2115# 0.12fF
C326 a_n739_619# gnd 0.21fF
C327 s3 a_3445_1607# 0.14fF
C328 w_154_2736# a_55_2747# 0.10fF
C329 w_1072_1940# a_64_1943# 0.14fF
C330 a_726_400# gnd 0.03fF
C331 w_762_1016# a_775_1022# 0.02fF
C332 a_3404_110# s1 0.08fF
C333 a_824_400# vdd 0.68fF
C334 a_n887_240# gnd 0.38fF
C335 p1 a_79_807# 0.72fF
C336 a_3421_2429# gnd 0.18fF
C337 w_n876_853# b1 0.09fF
C338 a_134_1415# gnd 0.10fF
C339 p3 a_752_2825# 0.15fF
C340 w_n724_2608# a_n779_2616# 0.10fF
C341 w_70_2566# a_n650_2818# 0.09fF
C342 a_3358_75# s1 0.72fF
C343 a_n843_1279# a_n843_1241# 0.41fF
C344 p3 w_3380_1631# 0.10fF
C345 w_n677_868# a_n727_879# 0.06fF
C346 a_775_1022# vdd 0.67fF
C347 a_n708_1523# a_n642_1486# 0.04fF
C348 a_n776_1523# a_n776_1469# 0.21fF
C349 w_n808_871# clk 0.10fF
C350 s1 gnd 0.05fF
C351 a_n844_1967# a_n844_1929# 0.41fF
C352 w_n658_1512# vdd 0.10fF
C353 w_66_799# a_n673_636# 0.10fF
C354 w_n661_2605# vdd 0.10fF
C355 w_118_799# a_19_810# 0.10fF
C356 c4 a_3363_2465# 0.08fF
C357 a_n863_861# vdd 0.41fF
C358 w_n888_647# clk 0.10fF
C359 a_179_1919# vdd 0.46fF
C360 2XOR_0/a_125_49# 2XOR_0/b 0.00fF
C361 a_n708_1931# gnd 0.21fF
C362 a_749_2650# a_756_2650# 0.47fF
C363 a_3408_488# s2 0.08fF
C364 w_34_629# a_n673_636# 0.09fF
C365 a_19_810# vdd 0.21fF
C366 a_1060_2722# gnd 0.52fF
C367 w_n717_2205# a_n704_2213# 0.05fF
C368 w_746_3026# vdd 0.15fF
C369 a_752_2825# gnd 0.35fF
C370 a_n852_2837# vdd 0.41fF
C371 p4 a_749_2650# 0.15fF
C372 a_824_400# a_3420_417# 0.04fF
C373 clk a_n779_2616# 0.03fF
C374 w_n752_665# a_n739_673# 0.05fF
C375 a_n875_655# vdd 0.41fF
C376 a_n746_61# w_n759_53# 0.05fF
C377 w_n895_35# clk 0.10fF
C378 p3 a_36_2118# 0.08fF
C379 w_n661_2605# a_n711_2616# 0.06fF
C380 w_n658_1512# a_n642_1486# 0.05fF
C381 w_3401_445# s2 0.03fF
C382 w_713_394# a_720_432# 0.09fF
C383 a_3408_488# gnd 0.37fF
C384 a_3439_1674# vdd 0.21fF
C385 a_n819_296# vdd 0.45fF
C386 in a_50_1275# 0.08fF
C387 p0 vdd 0.41fF
C388 w_n764_288# a_n819_296# 0.10fF
C389 p3 a_96_2083# 0.10fF
C390 a_36_2118# gnd 0.37fF
C391 w_51_1937# vdd 0.22fF
C392 a_n638_2176# vdd 0.95fF
C393 a_3416_39# w_3397_67# 0.10fF
C394 w_n895_35# a0 0.09fF
C395 p3 w_748_2142# 0.09fF
C396 p0 w_3345_n381# 0.10fF
C397 2NAND1_0/out 2NAND1_0/a_3_n40# 0.21fF
C398 clk a_n776_1985# 0.03fF
C399 a_n727_879# a_n727_825# 0.21fF
C400 a_83_2572# a_198_2548# 0.04fF
C401 w_83_2107# a_n638_2176# 0.10fF
C402 w_n666_2844# vdd 0.10fF
C403 a_n716_2855# vdd 0.27fF
C404 a_n716_2801# gnd 0.21fF
C405 a_751_2471# a_774_2471# 0.05fF
C406 a_19_810# a_20_727# 0.17fF
C407 a_96_2083# gnd 0.10fF
C408 w_n860_2590# a4 0.09fF
C409 c5 a_1052_2722# 0.05fF
C410 a_3363_2465# vdd 0.49fF
C411 w_n721_1977# a_n708_1985# 0.05fF
C412 a_1036_2722# a_1044_2722# 0.52fF
C413 2XOR_0/a vdd 0.95fF
C414 vdd 2NAND1_0/w_n10_n2# 0.22fF
C415 a_n852_2837# a_n852_2799# 0.41fF
C416 a_55_2747# gnd 0.37fF
C417 p3 a_162_611# 0.11fF
C418 a_n739_673# a_n739_619# 0.21fF
C419 clk b0 0.07fF
C420 a_3408_488# w_3349_445# 0.07fF
C421 p3 a_165_1251# 0.68fF
C422 w_37_1269# vdd 0.22fF
C423 a_752_2825# a_749_2650# 1.54fF
C424 a_n707_1297# vdd 0.27fF
C425 a_3439_1674# a_3393_1639# 0.51fF
C426 w_n740_871# vdd 0.08fF
C427 a_n642_1948# vdd 0.67fF
C428 a_n779_2562# gnd 0.21fF
C429 clk a_n784_2855# 0.03fF
C430 a_3362_453# s2 0.72fF
C431 a_947_1072# gnd 0.31fF
C432 p3 w_745_2535# 0.12fF
C433 c4 w_3350_2457# 0.10fF
C434 a_n776_1523# vdd 0.45fF
C435 a_n776_1469# gnd 0.21fF
C436 w_n820_665# vdd 0.08fF
C437 a_n642_1948# a_96_2115# 0.08fF
C438 a_162_611# gnd 0.52fF
C439 a_n661_842# gnd 0.29fF
C440 p1 a_83_2572# 0.10fF
C441 s3 a_3393_1607# 0.10fF
C442 inverter1_7/w_n19_78# a_720_432# 0.06fF
C443 a_165_1251# gnd 0.17fF
C444 p3 a_720_432# 0.10fF
C445 w_713_394# vdd 0.15fF
C446 w_1023_2786# c5 0.18fF
C447 inverter1_4/w_n19_78# p3 0.07fF
C448 c4 p3 0.01fF
C449 w_83_2107# a_n642_1948# 0.10fF
C450 a_3404_110# a_720_432# 0.00fF
C451 w_135_2107# a_36_2118# 0.10fF
C452 a_79_775# gnd 0.10fF
C453 inverter1_1/w_n19_78# a_3421_2429# 0.05fF
C454 w_n827_53# vdd 0.08fF
C455 w_3397_n381# s0 0.03fF
C456 w_37_1269# a_n642_1486# 0.09fF
C457 a_47_635# gnd 0.09fF
C458 a_932_1072# a_762_1127# 0.08fF
C459 w_n856_1271# a_n843_1241# 0.07fF
C460 a_3358_75# a_720_432# 0.08fF
C461 w_n792_2608# a_n779_2616# 0.05fF
C462 w_n785_2205# clk 0.10fF
C463 w_163_1945# a_64_1943# 0.06fF
C464 w_21_2061# vdd 0.11fF
C465 p0 a_3404_n338# 0.12fF
C466 2XOR_0/a_79_n18# p0 0.10fF
C467 w_926_1117# a_762_1127# 0.12fF
C468 s3 gnd 0.05fF
C469 2XOR_0/a_137_n22# gnd 0.18fF
C470 gnd a_720_432# 0.53fF
C471 w_n721_1515# vdd 0.08fF
C472 w_n729_2847# a_n784_2855# 0.10fF
C473 inverter1_2/w_n19_78# vdd 0.12fF
C474 c4 gnd 0.19fF
C475 w_n724_2608# vdd 0.08fF
C476 a_83_2528# gnd 0.21fF
C477 c5 vdd 1.24fF
C478 w_753_1700# a_720_432# 0.14fF
C479 a_n776_1931# gnd 0.21fF
C480 a_n751_242# gnd 0.21fF
C481 w_n740_871# a_n795_879# 0.10fF
C482 w_n717_2205# a_n772_2213# 0.10fF
C483 w_40_2690# a_56_2664# 0.05fF
C484 w_154_2736# a_115_2744# 0.14fF
C485 clk a_n847_2560# 0.12fF
C486 a_50_1275# a_775_1022# 0.41fF
C487 a_n704_2213# a_n704_2159# 0.21fF
C488 w_3_836# a_19_810# 0.05fF
C489 2NAND1_0/out inverter1_0/w_n19_78# 0.06fF
C490 2XOR_0/a 2XOR_0/b 0.56fF
C491 a_64_1943# a_64_1899# 0.21fF
C492 2XOR_0/b 2NAND1_0/w_n10_n2# 0.09fF
C493 clk vdd 2.04fF
C494 2XOR_0/a_125_49# 2XOR_0/w_118_6# 0.10fF
C495 w_n724_2608# a_n711_2616# 0.05fF
C496 w_n658_1512# a_n708_1523# 0.06fF
C497 a_3451_1603# s3 0.13fF
C498 a_751_2471# c5 0.15fF
C499 p3 p2 2.17fF
C500 a_83_2572# a_n645_2579# 0.08fF
C501 w_n820_665# a_n807_673# 0.05fF
C502 a_n840_2195# a_n840_2157# 0.41fF
C503 p4 a_3409_2500# 0.12fF
C504 p1 inverter1_8/w_n19_78# 0.07fF
C505 2XOR_0/a_125_49# p0 0.08fF
C506 p2 a_82_1415# 0.10fF
C507 w_37_1269# in 0.09fF
C508 w_7_1393# vdd 0.11fF
C509 w_3350_2457# vdd 0.12fF
C510 in a_n707_1297# 0.04fF
C511 w_3402_2457# s4 0.03fF
C512 a_n704_2213# vdd 0.27fF
C513 w_3349_445# a_3362_453# 0.05fF
C514 a_n704_2159# gnd 0.21fF
C515 s2 vdd 0.09fF
C516 w_n658_1974# vdd 0.10fF
C517 p4 a_56_2664# 0.13fF
C518 inverter1_7/w_n19_78# vdd 0.11fF
C519 a_n645_2579# a_56_2664# 0.04fF
C520 a_749_2650# a_162_611# 0.21fF
C521 p2 gnd 0.10fF
C522 p3 vdd 1.24fF
C523 a_762_1127# a_769_1127# 0.36fF
C524 w_n666_2844# a_n650_2818# 0.05fF
C525 a_n887_278# vdd 0.41fF
C526 a_n716_2855# a_n650_2818# 0.04fF
C527 clk a_n844_1929# 0.12fF
C528 a_3404_110# vdd 0.21fF
C529 a_939_1072# a_947_1072# 0.31fF
C530 p2 w_753_1700# 0.14fF
C531 p3 a_96_2115# 0.72fF
C532 a_932_1072# w_3380_1631# 0.10fF
C533 a_n847_2560# gnd 0.38fF
C534 w_n729_2847# vdd 0.08fF
C535 a_n784_2801# gnd 0.21fF
C536 a_3358_75# vdd 0.49fF
C537 2XOR_0/a 2XOR_0/a_125_49# 0.12fF
C538 a_n727_879# a_n661_842# 0.04fF
C539 a_n795_879# a_n795_825# 0.21fF
C540 c5 a_1044_2722# 0.05fF
C541 w_n759_53# a_n814_61# 0.10fF
C542 gnd vdd 1.31fF
C543 w_n721_1977# a_n776_1985# 0.10fF
C544 clk a_n795_879# 0.03fF
C545 a_3420_417# s2 0.13fF
C546 w_746_3026# a_179_1919# 0.09fF
C547 a_3363_2465# s4 0.72fF
C548 p3 a_751_2471# 0.15fF
C549 w_3397_67# s1 0.03fF
C550 a_751_2471# a_758_2471# 0.57fF
C551 inverter1_6/w_n19_78# a_3408_488# 0.05fF
C552 w_n865_2829# b4 0.09fF
C553 w_753_1700# vdd 0.09fF
C554 a_3421_2429# a_3409_2500# 0.17fF
C555 a_3416_n409# w_3397_n381# 0.10fF
C556 w_3345_n381# gnd 0.10fF
C557 clk a_n807_673# 0.03fF
C558 w_n657_1286# vdd 0.10fF
C559 a_n775_1297# vdd 0.45fF
C560 w_n853_2187# b3 0.09fF
C561 clk a_n852_2799# 0.12fF
C562 a_n711_2616# gnd 0.05fF
C563 a_751_2471# gnd 0.35fF
C564 a_n807_673# a_n807_619# 0.21fF
C565 a_n642_1486# gnd 0.29fF
C566 p2 w_3349_445# 0.10fF
C567 a_n844_1929# gnd 0.38fF
C568 a_3420_417# gnd 0.18fF
C569 a_3451_1603# vdd 0.21fF
C570 a_162_611# a_761_1890# 0.27fF
C571 w_37_1269# a_50_1275# 0.02fF
C572 w_n876_853# vdd 0.08fF
C573 a_777_1127# gnd 0.31fF
C574 w_7_1393# in 0.06fF
C575 w_3397_n381# a_3358_n373# 0.14fF
C576 w_69_1439# a_82_1447# 0.05fF
C577 w_121_1439# out 0.10fF
C578 w_4_753# vdd 0.11fF
C579 a_n642_1948# a_37_2035# 0.04fF
C580 a_759_2988# gnd 0.21fF
C581 w_n856_1271# a_n843_1279# 0.01fF
C582 w_3349_445# vdd 0.12fF
C583 w_1023_2786# a_749_2650# 0.12fF
C584 w_n853_2187# clk 0.10fF
C585 w_39_2773# a_55_2747# 0.05fF
C586 a_20_727# gnd 0.18fF
C587 w_20_2144# a_36_2118# 0.05fF
C588 a_759_3032# a_752_2825# 1.85fF
C589 inverter1_1/w_n19_78# c4 0.06fF
C590 p2 a_749_2650# 0.15fF
C591 w_n701_285# vdd 0.10fF
C592 p3 a_759_1645# 0.15fF
C593 w_n789_1515# vdd 0.08fF
C594 c4 a_761_1890# 0.15fF
C595 w_n797_2847# a_n784_2855# 0.05fF
C596 w_n792_2608# vdd 0.08fF
C597 out a_82_1447# 0.12fF
C598 p1 a_762_1127# 0.15fF
C599 2XOR_0/w_118_6# p0 0.03fF
C600 clk b2 0.07fF
C601 p3 w_755_1935# 0.12fF
C602 w_n785_2205# a_n772_2213# 0.05fF
C603 c4 w_1072_1940# 0.21fF
C604 a_n852_2799# gnd 0.38fF
C605 a_932_1072# a_947_1072# 0.05fF
C606 2XOR_0/b gnd 0.29fF
C607 a_3416_39# s1 0.13fF
C608 w_40_2690# a_n645_2579# 0.06fF
C609 a_726_356# gnd 0.21fF
C610 w_748_2142# a_761_2148# 0.02fF
C611 w_135_2107# a_96_2115# 0.14fF
C612 w_51_1937# a_n638_2176# 0.09fF
C613 w_21_2061# a_37_2035# 0.05fF
C614 a_749_2650# vdd 1.12fF
C615 a_932_1072# a_162_611# 0.05fF
C616 in gnd 0.29fF
C617 inverter1_9/w_n19_78# gnd 0.06fF
C618 a_759_1645# gnd 0.32fF
C619 w_n857_1959# a3 0.09fF
C620 a_3404_n338# gnd 0.37fF
C621 2XOR_0/a_79_n18# gnd 0.10fF
C622 w_n721_1515# a_n708_1523# 0.05fF
C623 a_3451_1603# a_3393_1639# 0.12fF
C624 s1 a_3410_43# 0.14fF
C625 w_753_1700# a_759_1645# 0.21fF
C626 a_50_1275# a_50_1231# 0.21fF
C627 w_66_799# a_n661_842# 0.10fF
C628 a_774_1645# a_782_1645# 0.41fF
C629 w_n657_1286# in 0.05fF
C630 a_n814_7# gnd 0.21fF
C631 p1 a_726_400# 0.08fF
C632 w_4_753# a_20_727# 0.05fF
C633 w_34_629# a_n661_842# 0.09fF
C634 a_n727_879# vdd 0.27fF
C635 w_118_799# a_79_807# 0.14fF
C636 a_n746_61# vdd 0.27fF
C637 p3 w_746_2870# 0.12fF
C638 w_3402_2457# a_3363_2465# 0.14fF
C639 a_932_1072# a_720_432# 0.10fF
C640 a_n772_2159# gnd 0.21fF
C641 a_n772_2213# vdd 0.45fF
C642 a_751_2471# a_749_2650# 1.25fF
C643 w_n721_1977# vdd 0.08fF
C644 a_79_807# vdd 0.49fF
C645 w_n888_647# a_n875_617# 0.07fF
C646 w_n900_270# clk 0.10fF
C647 p2 out 0.13fF
C648 a_162_611# a_761_2148# 0.05fF
C649 a_165_1251# a_761_2148# 0.08fF
C650 p2 a_761_1890# 0.15fF
C651 w_69_1439# vdd 0.12fF
C652 w_n666_2844# a_n716_2855# 0.06fF
C653 w_34_629# a_47_635# 0.02fF
C654 w_182_2574# vdd 0.13fF
C655 a_n739_673# vdd 0.27fF
C656 a_3404_n338# s0 0.08fF
C657 p3 w_743_2705# 0.14fF
C658 w_n797_2847# vdd 0.08fF
C659 a_n650_2818# gnd 0.29fF
C660 2XOR_0/a_125_49# gnd 0.37fF
C661 a_83_2572# a_162_611# 0.05fF
C662 w_811_394# a_726_400# 0.09fF
C663 a_55_2747# a_56_2664# 0.17fF
C664 a_165_1251# a_83_2572# 0.01fF
C665 a_n638_2176# a_n642_1948# 0.56fF
C666 inverter1_1/w_n19_78# vdd 0.11fF
C667 w_51_1937# a_n642_1948# 0.09fF
C668 out vdd 0.21fF
C669 p4 a_167_2712# 0.14fF
C670 a_3416_n409# vdd 0.21fF
C671 a_761_1890# vdd 0.87fF
C672 c5 a_1036_2722# 0.57fF
C673 w_n900_270# a_n887_278# 0.01fF
C674 a_775_1022# a_775_978# 0.21fF
C675 p3 a_37_2035# 0.13fF
C676 w_n789_1977# a_n776_1985# 0.05fF
C677 s4 gnd 0.05fF
C678 c4 a_761_2148# 0.15fF
C679 w_69_1439# a_n642_1486# 0.10fF
C680 w_1072_1940# vdd 0.09fF
C681 a_3404_110# w_3345_67# 0.07fF
C682 gnd a_3410_n405# 0.10fF
C683 w_n720_1289# vdd 0.08fF
C684 2XOR_0/a 2NAND1_0/w_n10_n2# 0.09fF
C685 inverter1_11/w_n19_78# a_n746_61# 0.06fF
C686 a_83_2572# a_720_432# 0.10fF
C687 a_50_1275# gnd 0.09fF
C688 a_759_1645# a_782_1645# 0.05fF
C689 w_3345_67# a_3358_75# 0.05fF
C690 a_83_2572# a_83_2528# 0.21fF
C691 a_n661_842# a_n673_636# 0.56fF
C692 inverter1_6/w_n19_78# p2 0.07fF
C693 a_932_1072# p2 0.01fF
C694 a_37_2035# gnd 0.18fF
C695 inverter1_3/w_n19_78# a_3451_1603# 0.05fF
C696 c4 a_3409_2500# 0.00fF
C697 a_n708_1523# gnd 0.05fF
C698 a_n844_1505# vdd 0.41fF
C699 a_20_727# a_79_807# 0.12fF
C700 vdd a_3358_n373# 0.49fF
C701 a_n673_636# a_47_635# 0.08fF
C702 2XOR_0/b a_n746_61# 0.04fF
C703 w_39_2773# vdd 0.12fF
C704 a_767_2825# gnd 0.31fF
C705 p3 a_179_1919# 0.05fF
C706 w_3345_n381# a_3358_n373# 0.05fF
C707 s0 a_3410_n405# 0.14fF
C708 inverter1_6/w_n19_78# vdd 0.12fF
C709 a_824_400# gnd 0.09fF
C710 a_932_1072# vdd 0.94fF
C711 a_752_2825# a_759_2825# 0.36fF
C712 a_162_611# a_64_1943# 0.07fF
C713 a_165_1251# a_64_1943# 0.05fF
C714 p4 a_752_2825# 0.15fF
C715 w_n860_2590# a_n847_2560# 0.07fF
C716 clk a_n819_296# 0.03fF
C717 w_926_1117# vdd 0.11fF
C718 clk a2 0.07fF
C719 s4 a_3415_2433# 0.14fF
C720 a_775_1022# gnd 0.13fF
C721 clk a_n882_5# 0.12fF
C722 a_1093_1885# a_1101_1885# 0.41fF
C723 w_121_1439# a_22_1450# 0.10fF
C724 w_69_1439# in 0.10fF
C725 w_66_799# vdd 0.12fF
C726 w_n857_1497# vdd 0.08fF
C727 w_n860_2590# vdd 0.08fF
C728 s2 a_3362_421# 0.10fF
C729 inverter1_0/w_n19_78# a_720_432# 0.05fF
C730 a_179_1919# gnd 0.07fF
C731 2XOR_0/inverter1_1/w_n19_78# 2XOR_0/a_137_n22# 0.05fF
C732 w_34_629# vdd 0.22fF
C733 w_1023_2786# a_83_2572# 0.12fF
C734 a_19_810# gnd 0.37fF
C735 p2 a_83_2572# 0.05fF
C736 a_3416_39# a_720_432# 0.04fF
C737 w_n832_288# vdd 0.08fF
C738 a_761_2148# vdd 0.47fF
C739 p3 a_3439_1674# 0.09fF
C740 c4 a_64_1943# 0.15fF
C741 a_n704_2213# a_n638_2176# 0.04fF
C742 a_n772_2213# a_n772_2159# 0.21fF
C743 a_22_1450# a_82_1447# 0.51fF
C744 in out 0.04fF
C745 w_21_2061# a_n642_1948# 0.06fF
C746 inverter1_9/w_n19_78# a_3416_n409# 0.05fF
C747 2XOR_0/w_66_6# 2XOR_0/a_79_14# 0.05fF
C748 a_n708_1985# a_n708_1931# 0.21fF
C749 a_759_1645# a_761_1890# 1.41fF
C750 a_n751_296# a_n751_242# 0.21fF
C751 a_3416_n409# a_3404_n338# 0.17fF
C752 w_20_2144# vdd 0.12fF
C753 a_47_591# gnd 0.21fF
C754 w_n721_1515# a_n776_1523# 0.10fF
C755 w_743_2705# a_749_2650# 0.21fF
C756 w_102_2736# a_n645_2579# 0.10fF
C757 w_1023_2786# a_759_3032# 0.12fF
C758 w_755_1935# a_761_1890# 0.12fF
C759 w_1072_1940# a_759_1645# 0.14fF
C760 a_3362_421# gnd 0.10fF
C761 p1 a_162_611# 0.27fF
C762 w_135_2107# a_37_2035# 0.10fF
C763 p1 a_165_1251# 0.16fF
C764 a_83_2572# vdd 0.70fF
C765 a_824_400# w_3349_445# 0.10fF
C766 a_3439_1674# gnd 0.37fF
C767 a_3409_2500# vdd 0.21fF
C768 p1 a_79_775# 0.10fF
C769 w_3350_2457# a_3363_2465# 0.05fF
C770 w_n876_853# a_n863_861# 0.01fF
C771 w_149_1277# a_165_1251# 0.05fF
C772 p0 gnd 0.49fF
C773 a_932_1072# a_3393_1639# 0.08fF
C774 a_n882_5# gnd 0.38fF
C775 a_n638_2176# gnd 0.29fF
C776 p1 w_745_2535# 0.12fF
C777 w_n789_1977# vdd 0.08fF
C778 p1 a_47_635# 0.17fF
C779 w_n677_868# a_n661_842# 0.05fF
C780 a_766_1645# a_774_1645# 0.41fF
C781 a_3445_1607# gnd 0.10fF
C782 a_3358_43# gnd 0.10fF
C783 w_n729_2847# a_n716_2855# 0.05fF
C784 a_56_2664# vdd 0.21fF
C785 clk a_n776_1523# 0.03fF
C786 2NAND1_0/out a_720_432# 0.04fF
C787 p1 a_720_432# 1.35fF
C788 a_759_3032# vdd 0.48fF
C789 w_n820_665# clk 0.10fF
C790 a_3404_n338# a_3358_n373# 0.51fF
C791 a_749_2650# a_764_2650# 0.05fF
C792 a_761_1890# a_768_1890# 0.36fF
C793 w_3432_1631# s3 0.03fF
C794 c4 p1 0.09fF
C795 a_83_2572# a_751_2471# 0.54fF
C796 w_n888_647# a1 0.09fF
C797 a_n673_636# vdd 0.67fF
C798 w_n865_2829# vdd 0.08fF
C799 a_n716_2855# gnd 0.05fF
C800 p4 a_55_2747# 0.08fF
C801 p2 a_22_1450# 0.08fF
C802 a_55_2747# a_n645_2579# 0.00fF
C803 p2 a_64_1943# 0.07fF
C804 a_3451_1603# a_3439_1674# 0.17fF
C805 w_n689_662# a_n739_673# 0.06fF
C806 w_n658_1974# a_n642_1948# 0.05fF
C807 w_n827_53# clk 0.10fF
C808 w_811_394# a_47_635# 0.09fF
C809 vdd inverter1_0/w_n19_78# 0.13fF
C810 clk b3 0.07fF
C811 2XOR_0/inverter1_1/w_n19_78# vdd 0.11fF
C812 2XOR_0/a gnd 0.29fF
C813 a_198_2548# vdd 0.21fF
C814 a_22_1450# vdd 0.21fF
C815 a_64_1943# vdd 0.85fF
C816 p4 a_165_1251# 0.02fF
C817 gnd a_3358_n405# 0.10fF
C818 a_3416_39# vdd 0.21fF
C819 a_n751_296# vdd 0.27fF
C820 w_n788_1289# vdd 0.08fF
C821 c4 a_1101_1885# 0.05fF
C822 a_769_1127# a_777_1127# 0.31fF
C823 a_n707_1297# gnd 0.05fF
C824 a_n843_1279# vdd 0.41fF
C825 inverter1_8/w_n19_78# vdd 0.12fF
C826 a_768_1890# a_776_1890# 0.31fF
C827 w_n764_288# a_n751_296# 0.05fF
C828 a_n642_1948# gnd 0.29fF
C829 a_n814_61# vdd 0.45fF
C830 w_70_2566# a_83_2572# 0.02fF
C831 p3 a_148_2083# 0.14fF
C832 w_163_1945# vdd 0.13fF
C833 p4 w_745_2535# 0.12fF
C834 w_n895_35# a_n882_43# 0.01fF
C835 a_56_2664# a_115_2744# 0.12fF
C836 w_39_2773# a_n650_2818# 0.07fF
C837 a_759_3032# a_759_2988# 0.21fF
C838 w_n657_1286# a_n707_1297# 0.06fF
C839 a_759_1645# a_766_1645# 0.47fF
C840 p2 p1 1.25fF
C841 w_n857_1497# b2 0.09fF
C842 a_824_400# a_824_356# 0.21fF
C843 inverter1_3/w_n19_78# a_932_1072# 0.06fF
C844 c4 p4 0.29fF
C845 a_n642_1486# a_22_1450# 0.12fF
C846 s0 a_3358_n405# 0.10fF
C847 a_751_2471# a_782_2471# 0.05fF
C848 a_19_810# a_79_807# 0.51fF
C849 a_n673_636# a_20_727# 0.04fF
C850 a_148_2083# gnd 0.10fF
C851 a_762_1127# a_720_432# 0.08fF
C852 p1 w_118_799# 0.03fF
C853 w_n860_2590# a_n847_2598# 0.01fF
C854 s4 a_3363_2433# 0.10fF
C855 vdd 2NAND1_0/out 0.60fF
C856 p1 vdd 1.34fF
C857 w_n865_2829# a_n852_2799# 0.07fF
C858 c5 gnd 0.15fF
C859 2XOR_0/a w_n701_285# 0.05fF
C860 a_932_1072# a_50_1275# 0.15fF
C861 a_3408_488# w_3401_445# 0.10fF
C862 w_149_1277# vdd 0.13fF
C863 a_50_1231# gnd 0.21fF
C864 w_n853_2187# a_n840_2157# 0.07fF
C865 a_47_635# a_726_400# 0.17fF
C866 w_926_1117# a_50_1275# 0.12fF
C867 w_6_1476# a_22_1450# 0.05fF
C868 clk a0 0.07fF
C869 w_n677_868# vdd 0.10fF
C870 w_40_2690# vdd 0.11fF
C871 a_775_978# gnd 0.21fF
C872 2XOR_0/inverter1_1/w_n19_78# 2XOR_0/b 0.06fF
C873 w_n752_665# vdd 0.08fF
C874 w_n654_2202# vdd 0.10fF
C875 p1 a_751_2471# 0.25fF
C876 a_115_2712# gnd 0.10fF
C877 a_n795_825# gnd 0.21fF
C878 clk gnd 1.37fF
C879 w_811_394# vdd 0.14fF
C880 w_n789_1515# a_n776_1523# 0.05fF
C881 p4 p2 0.12fF
C882 a_n707_1297# a_n707_1243# 0.21fF
C883 a_165_1251# a_752_2825# 0.08fF
C884 a_131_775# gnd 0.10fF
C885 a_22_1450# in 0.00fF
C886 c4 a_3421_2429# 0.04fF
C887 2XOR_0/a_137_n22# 2XOR_0/a_79_14# 0.12fF
C888 w_n759_53# vdd 0.08fF
C889 a_64_1943# a_759_1645# 0.46fF
C890 a_n807_619# gnd 0.21fF
C891 a_n819_296# a_n819_242# 0.21fF
C892 a_3409_2500# s4 0.08fF
C893 p2 a_762_1127# 0.15fF
C894 a_932_1072# a_775_1022# 0.15fF
C895 w_102_2736# a_55_2747# 0.07fF
C896 a_n704_2213# gnd 0.05fF
C897 a_n840_2195# vdd 0.41fF
C898 clk a_n775_1297# 0.03fF
C899 s2 gnd 0.05fF
C900 w_n857_1959# vdd 0.08fF
C901 2XOR_0/a_131_n18# p0 0.14fF
C902 w_926_1117# a_775_1022# 0.12fF
C903 a_3404_110# a_3358_75# 0.51fF
C904 a_3393_1607# gnd 0.10fF
C905 inverter1_5/w_n19_78# vdd 0.11fF
C906 p3 gnd 0.19fF
C907 p4 vdd 1.23fF
C908 p1 a_20_727# 0.13fF
C909 clk a_n844_1467# 0.12fF
C910 a_n645_2579# vdd 0.67fF
C911 a_82_1415# gnd 0.10fF
C912 a_3404_110# gnd 0.37fF
C913 w_3432_1631# a_3393_1639# 0.14fF
C914 a_n814_61# a_n814_7# 0.21fF
C915 p3 w_753_1700# 0.14fF
C916 a_762_1127# vdd 0.93fF
C917 w_n740_871# a_n727_879# 0.05fF
C918 w_n876_853# clk 0.10fF
C919 a_1052_2722# a_1060_2722# 0.52fF
C920 w_66_799# a_19_810# 0.07fF
C921 2XOR_0/b 2NAND1_0/out 0.08fF
C922 a_764_2650# a_772_2650# 0.41fF
C923 a_n779_2616# a_n779_2562# 0.21fF
C924 w_n857_1959# a_n844_1929# 0.07fF
C925 a_3408_488# a_3362_453# 0.51fF
C926 w_n689_662# a_n673_636# 0.05fF
C927 p4 a_751_2471# 0.15fF
C928 a_n645_2579# a_n711_2616# 0.04fF
C929 p1 a_759_1645# 0.25fF
C930 inverter1_5/w_n19_78# a_3420_417# 0.05fF
C931 a_932_1072# a_3439_1674# 0.00fF
C932 a_749_2650# c5 0.15fF
C933 w_n752_665# a_n807_673# 0.10fF
C934 p2 a_134_1415# 0.14fF
C935 w_n789_1515# clk 0.10fF
C936 a_n708_1985# vdd 0.27fF
C937 c4 a_1093_1885# 0.05fF
C938 w_n856_1271# vdd 0.08fF
C939 w_n792_2608# clk 0.10fF
C940 w_748_2142# a_165_1251# 0.09fF
C941 w_3401_445# a_3362_453# 0.14fF
C942 a_726_400# vdd 0.73fF
C943 a_179_1919# a_83_2572# 0.05fF
C944 p4 a_115_2744# 0.72fF
C945 a_n844_1467# gnd 0.38fF
C946 2XOR_0/w_66_6# vdd 0.12fF
C947 gnd s0 0.05fF
C948 a_n645_2579# a_115_2744# 0.08fF
C949 a_762_1127# a_777_1127# 0.05fF
C950 w_1023_2786# a_752_2825# 0.12fF
C951 a_3451_1603# gnd 0.18fF
C952 a_3421_2429# vdd 0.21fF
C953 inverter1_10/w_n19_78# vdd 0.12fF
C954 w_n720_1289# a_n707_1297# 0.05fF
C955 a_n711_2616# a_n711_2562# 0.21fF
C956 2XOR_0/a_79_14# vdd 0.49fF
C957 w_n832_288# a_n819_296# 0.05fF
C958 a_n882_43# vdd 0.41fF
C959 s1 vdd 0.09fF
C960 w_70_2566# a_n645_2579# 0.09fF
C961 a_n863_861# a_n863_823# 0.41fF
C962 p3 w_135_2107# 0.03fF
C963 a_179_1919# a_759_3032# 0.08fF
C964 a_165_1251# a_162_611# 0.15fF
C965 w_746_3026# a_759_3032# 0.02fF
C966 a_3415_2433# gnd 0.10fF
C967 w_20_2144# a_n638_2176# 0.07fF
C968 a_752_2825# vdd 0.84fF
C969 p3 a_749_2650# 0.15fF
C970 a_1085_1885# a_1093_1885# 0.41fF
C971 p1 w_756_1172# 0.12fF
C972 a_19_810# a_n673_636# 0.00fF
C973 clk a_n772_2213# 0.03fF
C974 a_751_2471# a_766_2471# 0.05fF
C975 p2 a_3408_488# 0.12fF
C976 a_761_2104# gnd 0.21fF
C977 w_3380_1631# vdd 0.12fF
C978 w_n865_2829# a_n852_2837# 0.01fF
C979 a_3409_2500# w_3402_2457# 0.10fF
C980 a_162_611# a_47_635# 0.11fF
C981 w_n853_2187# a_n840_2195# 0.01fF
C982 a_n707_1243# gnd 0.21fF
C983 a_n875_655# a_n875_617# 0.41fF
C984 a_782_1645# gnd 0.41fF
C985 2XOR_0/inverter1_0/w_n19_78# vdd 0.12fF
C986 a_162_611# a_720_432# 0.25fF
C987 w_n797_2847# clk 0.10fF
C988 p1 a_50_1275# 0.10fF
C989 a_165_1251# a_720_432# 0.07fF
C990 a_749_2650# gnd 0.25fF
C991 a_179_1919# a_64_1943# 0.12fF
C992 a_n776_1985# a_n776_1931# 0.21fF
C993 c4 a_165_1251# 0.06fF
C994 a_3408_488# vdd 0.21fF
C995 w_n717_2205# vdd 0.08fF
C996 p1 w_3345_67# 0.10fF
C997 w_149_1277# a_50_1275# 0.06fF
C998 w_163_1945# a_179_1919# 0.05fF
C999 w_n808_871# vdd 0.08fF
C1000 w_745_2535# a_720_432# 0.12fF
C1001 a_36_2118# vdd 0.21fF
C1002 w_102_2736# vdd 0.12fF
C1003 a_3410_n405# Gnd 0.01fF
C1004 a_3358_n405# Gnd 0.01fF
C1005 s0 Gnd 0.16fF
C1006 a_3358_n373# Gnd 0.08fF
C1007 vdd Gnd 174.87fF
C1008 gnd Gnd 105.72fF
C1009 a_n746_7# Gnd 0.01fF
C1010 a_n814_7# Gnd 0.01fF
C1011 a_3410_43# Gnd 0.01fF
C1012 a_3358_43# Gnd 0.01fF
C1013 s1 Gnd 2.06fF
C1014 a_3358_75# Gnd 0.11fF
C1015 a_n814_61# Gnd 0.85fF
C1016 a_n882_5# Gnd 1.36fF
C1017 a0 Gnd 0.33fF
C1018 a_n751_242# Gnd 0.01fF
C1019 a_n819_242# Gnd 0.01fF
C1020 a_n751_296# Gnd 0.45fF
C1021 a_n819_296# Gnd 0.85fF
C1022 a_n887_240# Gnd 1.36fF
C1023 b0 Gnd 0.33fF
C1024 a_824_356# Gnd 0.01fF
C1025 a_726_356# Gnd 0.01fF
C1026 a_3414_421# Gnd 0.01fF
C1027 a_3362_421# Gnd 0.01fF
C1028 a_726_400# Gnd 1.66fF
C1029 s2 Gnd 0.16fF
C1030 a_47_591# Gnd 0.01fF
C1031 a_n739_619# Gnd 0.01fF
C1032 a_n807_619# Gnd 0.01fF
C1033 a_47_635# Gnd 4.64fF
C1034 a_n739_673# Gnd 0.45fF
C1035 a_n807_673# Gnd 0.85fF
C1036 a_n875_617# Gnd 1.36fF
C1037 a1 Gnd 0.33fF
C1038 a_131_775# Gnd 0.01fF
C1039 a_79_775# Gnd 0.01fF
C1040 a_79_807# Gnd 0.08fF
C1041 a_20_727# Gnd 1.15fF
C1042 a_n673_636# Gnd 10.47fF
C1043 a_19_810# Gnd 1.92fF
C1044 a_n727_825# Gnd 0.01fF
C1045 a_n795_825# Gnd 0.01fF
C1046 a_n661_842# Gnd 7.51fF
C1047 a_n727_879# Gnd 0.45fF
C1048 a_n795_879# Gnd 0.85fF
C1049 a_n863_823# Gnd 1.36fF
C1050 b1 Gnd 0.33fF
C1051 a_775_978# Gnd 0.01fF
C1052 a_947_1072# Gnd 0.01fF
C1053 a_939_1072# Gnd 0.01fF
C1054 a_777_1127# Gnd 0.01fF
C1055 a_769_1127# Gnd 0.01fF
C1056 a_775_1022# Gnd 3.89fF
C1057 a_762_1127# Gnd 2.58fF
C1058 a_50_1231# Gnd 0.01fF
C1059 a_n707_1243# Gnd 0.01fF
C1060 a_n775_1243# Gnd 0.01fF
C1061 a_50_1275# Gnd 4.47fF
C1062 a_n707_1297# Gnd 0.45fF
C1063 a_n775_1297# Gnd 0.85fF
C1064 a_n843_1241# Gnd 1.36fF
C1065 a2 Gnd 0.33fF
C1066 a_134_1415# Gnd 0.01fF
C1067 a_82_1415# Gnd 0.01fF
C1068 a_82_1447# Gnd 0.11fF
C1069 out Gnd 1.15fF
C1070 in Gnd 10.54fF
C1071 a_22_1450# Gnd 1.92fF
C1072 a_n708_1469# Gnd 0.01fF
C1073 a_n776_1469# Gnd 0.01fF
C1074 a_n642_1486# Gnd 7.60fF
C1075 a_n708_1523# Gnd 0.45fF
C1076 a_n776_1523# Gnd 0.85fF
C1077 a_n844_1467# Gnd 1.36fF
C1078 b2 Gnd 0.33fF
C1079 a_3445_1607# Gnd 0.01fF
C1080 a_3393_1607# Gnd 0.01fF
C1081 s3 Gnd 0.16fF
C1082 a_3393_1639# Gnd 0.08fF
C1083 a_782_1645# Gnd 0.01fF
C1084 a_774_1645# Gnd 0.01fF
C1085 a_766_1645# Gnd 0.01fF
C1086 a_1101_1885# Gnd 0.01fF
C1087 a_1093_1885# Gnd 0.01fF
C1088 a_1085_1885# Gnd 0.01fF
C1089 a_776_1890# Gnd 0.01fF
C1090 a_768_1890# Gnd 0.01fF
C1091 a_64_1899# Gnd 0.01fF
C1092 a_n708_1931# Gnd 0.01fF
C1093 a_n776_1931# Gnd 0.01fF
C1094 a_761_1890# Gnd 2.47fF
C1095 a_759_1645# Gnd 3.13fF
C1096 a_64_1943# Gnd 12.72fF
C1097 a_n708_1985# Gnd 0.45fF
C1098 a_n776_1985# Gnd 0.85fF
C1099 a_n844_1929# Gnd 1.36fF
C1100 a3 Gnd 0.33fF
C1101 a_148_2083# Gnd 0.01fF
C1102 a_96_2083# Gnd 0.01fF
C1103 a_761_2104# Gnd 0.01fF
C1104 a_96_2115# Gnd 0.08fF
C1105 a_761_2148# Gnd 1.86fF
C1106 a_37_2035# Gnd 1.15fF
C1107 a_n642_1948# Gnd 10.68fF
C1108 a_36_2118# Gnd 1.29fF
C1109 a_n704_2159# Gnd 0.01fF
C1110 a_n772_2159# Gnd 0.01fF
C1111 a_n638_2176# Gnd 7.85fF
C1112 a_n704_2213# Gnd 0.45fF
C1113 a_n772_2213# Gnd 0.85fF
C1114 a_n840_2157# Gnd 1.36fF
C1115 b3 Gnd 0.33fF
C1116 a_3415_2433# Gnd 0.01fF
C1117 a_3363_2433# Gnd 0.01fF
C1118 s4 Gnd 0.16fF
C1119 a_782_2471# Gnd 0.01fF
C1120 a_774_2471# Gnd 0.01fF
C1121 a_766_2471# Gnd 0.01fF
C1122 a_758_2471# Gnd 0.01fF
C1123 a_83_2528# Gnd 0.01fF
C1124 a_198_2548# Gnd 0.13fF
C1125 a_n711_2562# Gnd 0.01fF
C1126 a_n779_2562# Gnd 0.01fF
C1127 a_n711_2616# Gnd 0.45fF
C1128 a_772_2650# Gnd 0.01fF
C1129 a_764_2650# Gnd 0.01fF
C1130 a_756_2650# Gnd 0.01fF
C1131 a_n779_2616# Gnd 0.85fF
C1132 a_n847_2560# Gnd 1.36fF
C1133 a4 Gnd 0.33fF
C1134 a_1060_2722# Gnd 0.01fF
C1135 a_1052_2722# Gnd 0.01fF
C1136 a_1044_2722# Gnd 0.01fF
C1137 a_1036_2722# Gnd 0.01fF
C1138 a_167_2712# Gnd 0.01fF
C1139 a_115_2712# Gnd 0.01fF
C1140 a_162_611# Gnd 5.28fF
C1141 a_115_2744# Gnd 0.11fF
C1142 a_56_2664# Gnd 1.15fF
C1143 a_n645_2579# Gnd 11.05fF
C1144 c5 Gnd 6.47fF
C1145 a_55_2747# Gnd 1.92fF
C1146 a_749_2650# Gnd 2.60fF
C1147 a_751_2471# Gnd 2.92fF
C1148 a_83_2572# Gnd 6.47fF
C1149 a_767_2825# Gnd 0.01fF
C1150 a_759_2825# Gnd 0.01fF
C1151 a_n716_2801# Gnd 0.01fF
C1152 a_n784_2801# Gnd 0.01fF
C1153 a_n650_2818# Gnd 8.39fF
C1154 a_n716_2855# Gnd 0.45fF
C1155 a_752_2825# Gnd 2.26fF
C1156 a_n784_2855# Gnd 0.85fF
C1157 a_n852_2799# Gnd 1.36fF
C1158 b4 Gnd 0.33fF
C1159 clk Gnd 42.07fF
C1160 a_165_1251# Gnd 8.76fF
C1161 a_759_2988# Gnd 0.01fF
C1162 a_759_3032# Gnd 1.87fF
C1163 a_179_1919# Gnd 2.68fF
C1164 w_3397_n381# Gnd 1.16fF
C1165 w_3345_n381# Gnd 1.16fF
C1166 w_3397_67# Gnd 1.16fF
C1167 w_3345_67# Gnd 1.16fF
C1168 w_n759_53# Gnd 0.87fF
C1169 w_n827_53# Gnd 0.87fF
C1170 w_n895_35# Gnd 1.80fF
C1171 w_n701_285# Gnd 1.03fF
C1172 w_n764_288# Gnd 0.87fF
C1173 w_n832_288# Gnd 0.87fF
C1174 w_n900_270# Gnd 1.80fF
C1175 w_811_394# Gnd 1.09fF
C1176 w_713_394# Gnd 1.09fF
C1177 w_3401_445# Gnd 1.16fF
C1178 w_3349_445# Gnd 0.45fF
C1179 w_146_637# Gnd 1.03fF
C1180 w_34_629# Gnd 1.09fF
C1181 w_n689_662# Gnd 1.03fF
C1182 w_n752_665# Gnd 0.87fF
C1183 w_n820_665# Gnd 0.87fF
C1184 w_n888_647# Gnd 1.80fF
C1185 w_4_753# Gnd 1.03fF
C1186 w_118_799# Gnd 1.16fF
C1187 w_66_799# Gnd 1.16fF
C1188 w_3_836# Gnd 1.03fF
C1189 w_n677_868# Gnd 1.03fF
C1190 w_n740_871# Gnd 0.87fF
C1191 w_n808_871# Gnd 0.87fF
C1192 w_n876_853# Gnd 1.80fF
C1193 w_762_1016# Gnd 1.09fF
C1194 w_926_1117# Gnd 1.61fF
C1195 w_756_1172# Gnd 1.61fF
C1196 w_149_1277# Gnd 1.03fF
C1197 w_37_1269# Gnd 1.09fF
C1198 w_n657_1286# Gnd 1.03fF
C1199 w_n720_1289# Gnd 0.87fF
C1200 w_n788_1289# Gnd 0.87fF
C1201 w_n856_1271# Gnd 1.80fF
C1202 w_7_1393# Gnd 1.03fF
C1203 w_121_1439# Gnd 1.16fF
C1204 w_69_1439# Gnd 1.16fF
C1205 w_6_1476# Gnd 1.03fF
C1206 w_n658_1512# Gnd 1.03fF
C1207 w_n721_1515# Gnd 0.87fF
C1208 w_n789_1515# Gnd 0.87fF
C1209 w_n857_1497# Gnd 1.80fF
C1210 w_3432_1631# Gnd 1.16fF
C1211 w_3380_1631# Gnd 0.90fF
C1212 w_753_1700# Gnd 2.07fF
C1213 w_1072_1940# Gnd 2.07fF
C1214 w_755_1935# Gnd 1.61fF
C1215 w_163_1945# Gnd 1.03fF
C1216 w_51_1937# Gnd 1.09fF
C1217 w_n658_1974# Gnd 1.03fF
C1218 w_n721_1977# Gnd 0.87fF
C1219 w_n789_1977# Gnd 0.87fF
C1220 w_n857_1959# Gnd 1.80fF
C1221 w_21_2061# Gnd 1.03fF
C1222 w_748_2142# Gnd 1.09fF
C1223 w_135_2107# Gnd 1.16fF
C1224 w_83_2107# Gnd 1.16fF
C1225 w_20_2144# Gnd 1.03fF
C1226 w_n654_2202# Gnd 1.03fF
C1227 w_n717_2205# Gnd 0.87fF
C1228 w_n785_2205# Gnd 0.87fF
C1229 w_n853_2187# Gnd 1.80fF
C1230 w_3402_2457# Gnd 1.16fF
C1231 w_745_2535# Gnd 2.19fF
C1232 w_182_2574# Gnd 1.03fF
C1233 w_70_2566# Gnd 1.09fF
C1234 w_n661_2605# Gnd 1.03fF
C1235 w_n724_2608# Gnd 0.87fF
C1236 w_n792_2608# Gnd 0.87fF
C1237 w_n860_2590# Gnd 1.80fF
C1238 w_743_2705# Gnd 2.07fF
C1239 w_40_2690# Gnd 1.03fF
C1240 w_154_2736# Gnd 1.16fF
C1241 w_102_2736# Gnd 1.16fF
C1242 w_1023_2786# Gnd 2.19fF
C1243 w_39_2773# Gnd 0.99fF
C1244 w_746_2870# Gnd 1.61fF
C1245 w_n666_2844# Gnd 1.03fF
C1246 w_n729_2847# Gnd 0.87fF
C1247 w_n797_2847# Gnd 0.87fF
C1248 w_n865_2829# Gnd 1.80fF
C1249 w_746_3026# Gnd 1.09fF
C1250 a_n746_61# Gnd 0.47fF
C1251 inverter1_11/w_n19_78# Gnd 1.03fF
C1252 a_3404_n338# Gnd 1.97fF
C1253 p0 Gnd 28.19fF
C1254 inverter1_10/w_n19_78# Gnd 1.03fF
C1255 a_3416_n409# Gnd 1.16fF
C1256 inverter1_9/w_n19_78# Gnd 1.03fF
C1257 a_3404_110# Gnd 1.97fF
C1258 p1 Gnd 0.37fF
C1259 inverter1_8/w_n19_78# Gnd 1.03fF
C1260 2XOR_0/a_131_n18# Gnd 0.01fF
C1261 2XOR_0/a_79_n18# Gnd 0.01fF
C1262 2XOR_0/w_118_6# Gnd 1.16fF
C1263 2XOR_0/w_66_6# Gnd 0.48fF
C1264 2XOR_0/a_137_n22# Gnd 1.16fF
C1265 2XOR_0/inverter1_1/w_n19_78# Gnd 1.03fF
C1266 2XOR_0/a_125_49# Gnd 1.97fF
C1267 2XOR_0/a Gnd 6.53fF
C1268 2XOR_0/inverter1_0/w_n19_78# Gnd 1.03fF
C1269 a_3416_39# Gnd 1.16fF
C1270 inverter1_7/w_n19_78# Gnd 1.03fF
C1271 a_3408_488# Gnd 1.97fF
C1272 p2 Gnd 12.72fF
C1273 inverter1_6/w_n19_78# Gnd 1.03fF
C1274 a_3420_417# Gnd 1.16fF
C1275 a_824_400# Gnd 12.22fF
C1276 inverter1_5/w_n19_78# Gnd 1.03fF
C1277 a_3439_1674# Gnd 1.97fF
C1278 p3 Gnd 0.37fF
C1279 inverter1_4/w_n19_78# Gnd 1.03fF
C1280 a_3451_1603# Gnd 1.16fF
C1281 a_932_1072# Gnd 13.48fF
C1282 inverter1_3/w_n19_78# Gnd 1.03fF
C1283 a_3409_2500# Gnd 1.97fF
C1284 p4 Gnd 0.28fF
C1285 inverter1_2/w_n19_78# Gnd 1.03fF
C1286 a_3421_2429# Gnd 1.16fF
C1287 c4 Gnd 12.78fF
C1288 inverter1_1/w_n19_78# Gnd 1.03fF
C1289 a_720_432# Gnd 86.89fF
C1290 inverter1_0/w_n19_78# Gnd 1.03fF
C1291 2NAND1_0/a_3_n40# Gnd 0.01fF
C1292 2NAND1_0/out Gnd 0.30fF
C1293 2NAND1_0/w_n10_n2# Gnd 1.09fF
.control
tran 0.01n 50n
plot v(a0) v(a1)+2 v(a2)+4 v(a3)+6 v(a4)+8
plot v(b0) v(b1)+2 v(b2)+4 v(b3)+6 v(b4)+8
plot v(s0) v(s1)+2 v(s2)+4 v(s3)+6 v(s4)+8 V(clk)+10 v(b4)+12
plot v(c5)
plot v(p0) v(s0)+2

* Propagation delay: t(50% of s4) - t(50% of b0)
meas tran t_b0_50_rise  WHEN v(b0)=0.9 RISE=1
meas tran t_s4_50_rise  WHEN v(s4)=0.9 RISE=1

meas tran t_b0_50_fall  WHEN v(b0)=0.9 FALL=1
meas tran t_s4_50_fall  WHEN v(s4)=0.9 FALL=1
run
.endc

.end

* t_b0_50_rise        =  2.005000e-08
* t_s4_50_rise        =  2.069641e-08
* t_b0_50_fall        =  2.515000e-08
* t_s4_50_fall        =  2.581268e-08
* Propagation delay results:
* Rise delay  = t_s4_50_rise - t_b0_50_rise = 664.10 psec
* Fall delay  = t_s4_50_fall - t_b0_50_fall = 661.27 psec
