.include TSMC_180nm.txt
.param SUPPLY=1.8
.param LAMBDA=0.09u
.param width_N={10*LAMBDA}
.param width_P={2*width_N}
.global gnd vdd
.option scale=0.09u
Vdd vdd gnd 'SUPPLY'

Vin in gnd PULSE(0 'SUPPLY' 0 0 0 20ns 40ns)

M1000 out in vdd w_n19_80# CMOSP w=10 l=2
+  ad=70 pd=34 as=60 ps=32
M1001 out in gnd Gnd CMOSN w=4 l=2
+  ad=28 pd=22 as=24 ps=20
C0 out in 0.04fF
C1 in gnd 0.05fF
C2 out gnd 0.03fF
C3 in vdd 0.02fF
C4 in w_n19_80# 0.11fF
C5 out vdd 0.14fF
C6 out w_n19_80# 0.07fF
C7 w_n19_80# vdd 0.09fF
C8 gnd Gnd 0.17fF
C9 out Gnd 0.09fF
C10 vdd Gnd 0.04fF
C11 in Gnd 0.19fF
C12 w_n19_80# Gnd 0.97fF

.tran 0.1ns 160ns
.control
run
plot V(in) V(out)+2

.endc
.end
